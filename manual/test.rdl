// wide registers
// rollover, saturating counters, thresholds
// cascading counters
// name, description params
// external regfile

field swcfg_field {
     hw   = r; sw = rw;
     desc = "SW Configuration field";
};

field hwsts_field {
     hw   = w; sw = r;
     desc = "HW Status field";
};

field hwsw_field {
     hw   = rw; sw = rw;
     desc = "HW/SW R/W field";
};

reg memctl_reg {
    swcfg_field l_rwm_sel [11:11];
    swcfg_field l_rwm [10:8];
};

field rollover_incr_32b_field {
    sw=rw; counter; we; fieldwidth = 4; overflow; incrvalue = 4'd1; reset = 4'd0;
};

field sat_incr_rclr_16b_field {
    rclr; counter; we; fieldwidth = 16; saturate; incrvalue = 16'd1; reset = 16'd0;
};

field sat_incr_rclr_32b_field {
    rclr; counter; we; fieldwidth = 4; saturate; incrthreshold = 4'h8;  incrvalue = 4'd1; reset = 4'd0;
};


regfile estats {

		default reset = 0;
		
		reg {
		field {sw=rw; hw=r;} timer_sram;
		field {sw=rw; hw=r;} cbuf_fifo;
		field {sw=rw; hw=r;} lut_st;
		field {sw=rw; intr; hw=r;} l0_b0;
		field {sw=rw; intr; hw=r;} l0_b1;
		field {sw=rw; intr; halt; hw=r;} l0_b2;
		field {sw=rw; hw=r;} l0_b3;
		} disable_check [2] +=0x80;
		
		reg{
		field {sw=r;hw=na;}  version[31:30] = 2'd2;
		field {sw=r;hw=na;}  syn_logged[9:9] = 1'd0;
		field {sw=r;hw=na;}  wdth[8:4] = 5'd7;
		field {sw=r;hw=na;}  generator[3:3] = 1'd1;
		field {sw=r;hw=na;}  checker[2:2] = 1'd1;
		field {sw=r;hw=na;}  correctable[1:1] = 1'd0;
		field {sw=r;hw=na;}  adr_logged[0:0] = 1'd1;
		} features;
		
		reg{
		  field {sw=rw;hw=w;we;} value[10] = 10'd0;
		} log_address1;
		log_address1->desc="newdesc bla bla";
		
		reg{
		  desc = "newdesc 2 bla bla";
		  field {sw=rw;hw=w;we;} value[10] = 10'd0;
		} log_address2 %=0x10;
		
		reg{
		  regwidth = 128;
		  field {sw=rw;hw=rw;we;} value[96] = 96'ha5a5a5a5a5a5a5a5a5a5a5a5;
		} wide_reg %=0x10;
};

regfile erdr {

	reg {
        category = "STATE";
		swcfg_field ws_enable[31:31] = 1'd1;
		swcfg_field set_back[26:16] = 11'd16;
		swcfg_field size[10:0] = 11'd128;
	} reorder_window;

	reg {
		hwsts_field busy[16:16] = 1'd0;
		swcfg_field stream[9:0] = 10'd0;
	} stream_reconf;

    regfile cp_fp_wr_buffer_rf {
    	reg {
    	   hwsts_field addr0[26:16];
	   hwsts_field addr1[10:0];
    	} buffer[4]; 
    };

    external cp_fp_wr_buffer_rf cp_fp_wr @0x21c0; 
    
    reg { rollover_incr_32b_field count; } roll32_counter_reg;
    reg { sat_incr_rclr_32b_field count; dontcompare; } sat32_counter_reg;
 
    reg {
        swcfg_field en[31:31] = 1'd1;
        field {rclr; hw=w; we; } subch[30:26] = 5'd0;
        field {rclr; hw=w; we; 
                sub_category = "INFO";
              } str[25:16] = 10'd0;
        sat_incr_rclr_16b_field count[15:0];
    }  rcnt_sat_log;  
    rcnt_sat_log.count->incr = roll32_counter_reg.count->overflow;  // cascade some counters      
};

addrmap  {
	estats stats @0x1000;
	erdr rdr @0x4000;
	reg {
        name = "extra_reg name";
        desc = "extra_reg description bla bla bla
                more bla";
        swcfg_field value[31:0];
	} extra_reg;	
	
} simple1;    


