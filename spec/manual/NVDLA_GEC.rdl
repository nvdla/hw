// ================================================================
// NVDLA Open Source Project
//
// Copyright(c) 2016 - 2017 NVIDIA Corporation.  Licensed under the
// NVDLA Open Hardware License; Check "LICENSE" which comes with
// this distribution for more information.
// ================================================================

property spec_sw_default {
    type      = number;
    component = field;
};
property spec_access {
    type      = string;
    component = field;
};
property sw_default_mask {
    type      = number;
    component = field;
};
property reset_mask {
    type      = number;
    component = field;
};
regfile regs_NVDLA_GEC{
    default regwidth=32;
    reg {
        name = "FEATURE";
        desc = "
////Error Collator Registers
////==================================
//// GLOBAL SLICE
////==================================
";
        field {
            sw              = r;
            hw              = r;
            spec_access     = c;
            reset           = 0x43;
            reset_mask      = 0xffff;
            spec_sw_default = 0x0;
            sw_default_mask = 0x0;
        } NUM_ERR[31:16];
        NUM_ERR->desc="
//// Number of errors connected to this collator. This is passed as a build time option to the plugin
";
        field {
            sw              = r;
            hw              = r;
            spec_access     = c;
            reset           = 0x3;
            reset_mask      = 0x3f;
            spec_sw_default = 0x0;
            sw_default_mask = 0x0;
        } NUM_ERR_SLICES[5:0];
        NUM_ERR_SLICES->desc="
//// Number of error slices supported by this error collator, does not include the GlobalSpace and is 
//// derived by ceil (NUM_ERR/32). SW shall first read this register to determine the number of slices 
//// and read the required number of Error_Status registers .
";
    }FEATURE @0x0;
    reg {
        name = "SWRESET";
        field {
            sw              = w;
            hw              = r;
            spec_access     = w;
            reset           = 0x0;
            reset_mask      = 0x1;
            spec_sw_default = 0x0;
            sw_default_mask = 0x0;
        } SWRST[0:0];
        SWRST->desc="
//// 1'b1 : Issue a SW reset to the Error Collator. This will reset all the registers(Except SCR), counters 
////        and logic of the Error Collator. SW can use this bit to flush errors logged into the error collator 
////        for ex, after Boot, SC7/8 exit.
//// 1'b0 : Do nothing, reset value.
//// This bit is auto-cleared.
";
    }SWRESET @0x4;
    reg {
        name = "MISSIONERR_TYPE";
        field {
            sw              = r;
            hw              = w;
            spec_access     = r;
            reset           = 0x5;
            reset_mask      = 0x3f;
            spec_sw_default = 0x0;
            sw_default_mask = 0x0;
        } CODE[5:0];
        CODE->desc="
//// This register indicates the fault code of the register based on the value of MISSIONERR_INDEX Register. 
//// This can be used by a fault handling agent to triage an error without requiring device-specific code.The
//// possible values of this field are:
////   6'd0  : None
////   6'd1  : Parity Error on internal data path
////   6'd2  : ECC SEC Error on internal data path
////   6'd3  : ECC DED Error on internal data path
////   6'd4  : Comparator Error
////   6'd5  : Register Parity Error
////   6'd6  : Parity Error SEC Error from on-chip SRAM/Fifo
////   6'd7  : ECC SEC Error from on-chip SRAM/Fifo
////   6'd8  : ECC DED Error from on-chip SRAM/Fifo
////   6'd9  : Clock Monitor ErrorOther Error
////   6'd10 : Voltage Error
////   6'd11 : Temperature Error
////   6'd16 : SW Correctable Error
////   6'd17 : SW Un-Correctable Error
////   6'd32 : Other HW Correctable Error
////   6'd33 : Other HW Uncorrectable Error
//// All other values : Reserved for future use.
";
    }MISSIONERR_TYPE @0x8;
    reg {
        name = "CURRENT_COUNTER_VALUE";
        field {
            sw              = r;
            hw              = w;
            spec_access     = r;
            reset           = 0x0;
            reset_mask      = 0x1ff;
            spec_sw_default = 0x0;
            sw_default_mask = 0x0;
        } VALUE[8:0];
        VALUE->desc="
//// Provides the current value of the counter corresponding to the error in MissionErr_Index Register. 
//// Default provides the value of error 0 counter. 
//// Bit[8] is the ovrerflow bit post which the counter saturates and does not counter further. 
";
    }CURRENT_COUNTER_VALUE @0xc;
    reg {
        name = "MISSIONERR_INDEX";
        field {
            sw              = rw;
            hw              = r;
            spec_access     = rw;
            reset           = 0x0;
            reset_mask      = 0x7f;
            spec_sw_default = 0x0;
            sw_default_mask = 0x0;
        } IDX[6:0];
        IDX->desc="
//// BINARY Encoded. For error number 32, register should be programmed with value 0x20. 
//// Write to this register with Error number will update:
////   - MISSIONERR_TYPE Register with the Error-Code for the Error.
////   - CURRENT_COUNTER_VALUE Register with the error's SEC/DED Counter.
////   - MISSIONERR_USERVALUE with value of the first error_<i>_user signal.
//// SW can use this to trage the error.
//// number shall update the MISSIONERR_TYPE register with the error code and the Current_Counter_Value register 
//// with the value of the errors SEC/DED counter. SW can use this register to triage the error.
";
    }MISSIONERR_INDEX @0x14;
    reg {
        name = "CORRECTABLE_THRESHOLD";
        field {
            sw              = rw;
            hw              = r;
            spec_access     = rw;
            reset           = 0xff;
            reset_mask      = 0xff;
            spec_sw_default = 0x0;
            sw_default_mask = 0x0;
        } COUNT[7:0];
        COUNT->desc="
//// Threshold value for all SEC Fault Reporting Units connected to this error collator.
//// SEC Errors are logged once the threshold is reached and the overflow bit is set.
//// 7'b0  : Log SEC error after receiving 1 Error.
//// 7'b1  : Log SEC error after receiving 2 Errors. 
//// ...
//// 7'bFF : Log SEC error after receiving 256 Errors.
";
    }CORRECTABLE_THRESHOLD @0x18;
    reg {
        name = "MISSIONERR_INJECT_UNLOCK";
        enum MISSIONERR_INJECT_UNLOCK_VALUE_enum {
            LOCK = 8'd0;
            UNLOCK = 8'd225;
        };
        field {
            encode          = MISSIONERR_INJECT_UNLOCK_VALUE_enum;
            sw              = rw;
            hw              = r;
            spec_access     = rw;
            reset           = 0x0;
            reset_mask      = 0xff;
            spec_sw_default = 0x0;
            sw_default_mask = 0x0;
        } VALUE[7:0];
        VALUE->desc="
//// Writes to ERRSLICE_XXX_MISSIONERR_INJECT registers are disabled until this register is written with a value of 0xE1. 
//// This is to prevent an inadvertent safety error injection in the safety plugin due to: 
////  1. A fault on ERRSLICE_XXX_MISSIONERR_INJECT register itself.
////  2. Erroneous SW.
//// The register shall be written with a value of 0x0 to reestablish the lock after user has completed the error injection testing. 
//// 0xE1 : Unlock the MISSIONERR_INJECT Register
//// 0x0  : Lock the MISSIONERR_INJECT Register
";
    }MISSIONERR_INJECT_UNLOCK @0x1c;
    reg {
        name = "ERRSLICE0_MISSIONERR_ENABLE";
        desc = "
//// 0x20 to 0x2C = Reserved for future use.
////==================================
//// ERROR SLICE - 0
////==================================
";
        enum ERRSLICE0_MISSIONERR_ENABLE_ERR31_enum {
            DISABLE = 1'd0;
            ENABLE = 1'd1;
        };
        field {
            encode          = ERRSLICE0_MISSIONERR_ENABLE_ERR31_enum;
            sw              = rw;
            hw              = r;
            spec_access     = rw;
            reset           = 0x1;
            reset_mask      = 0x1;
            spec_sw_default = 0x0;
            sw_default_mask = 0x0;
        } ERR31[31:31];
        ERR31->desc="
////1'b1 -> Enable  Mission Error Reporting for ECC SEC Error from on-chip SRAM/Fifo from <NV_DLA>.<CACC>.<D0BUF>
////1'b0 -> Disable Mission Error Reporting for ECC SEC Error from on-chip SRAM/Fifo from <NV_DLA>.<CACC>.<D0BUF>
";
        enum ERRSLICE0_MISSIONERR_ENABLE_ERR30_enum {
            DISABLE = 1'd0;
            ENABLE = 1'd1;
        };
        field {
            encode          = ERRSLICE0_MISSIONERR_ENABLE_ERR30_enum;
            sw              = rw;
            hw              = r;
            spec_access     = rw;
            reset           = 0x1;
            reset_mask      = 0x1;
            spec_sw_default = 0x0;
            sw_default_mask = 0x0;
        } ERR30[30:30];
        ERR30->desc="
////1'b1 -> Enable  Mission Error Reporting for ECC DED Error from on-chip SRAM/Fifo from <NV_DLA>.<CACC>.<A7BUF>
////1'b0 -> Disable Mission Error Reporting for ECC DED Error from on-chip SRAM/Fifo from <NV_DLA>.<CACC>.<A7BUF>
";
        enum ERRSLICE0_MISSIONERR_ENABLE_ERR29_enum {
            DISABLE = 1'd0;
            ENABLE = 1'd1;
        };
        field {
            encode          = ERRSLICE0_MISSIONERR_ENABLE_ERR29_enum;
            sw              = rw;
            hw              = r;
            spec_access     = rw;
            reset           = 0x1;
            reset_mask      = 0x1;
            spec_sw_default = 0x0;
            sw_default_mask = 0x0;
        } ERR29[29:29];
        ERR29->desc="
////1'b1 -> Enable  Mission Error Reporting for ECC SEC Error from on-chip SRAM/Fifo from <NV_DLA>.<CACC>.<A7BUF>
////1'b0 -> Disable Mission Error Reporting for ECC SEC Error from on-chip SRAM/Fifo from <NV_DLA>.<CACC>.<A7BUF>
";
        enum ERRSLICE0_MISSIONERR_ENABLE_ERR28_enum {
            DISABLE = 1'd0;
            ENABLE = 1'd1;
        };
        field {
            encode          = ERRSLICE0_MISSIONERR_ENABLE_ERR28_enum;
            sw              = rw;
            hw              = r;
            spec_access     = rw;
            reset           = 0x1;
            reset_mask      = 0x1;
            spec_sw_default = 0x0;
            sw_default_mask = 0x0;
        } ERR28[28:28];
        ERR28->desc="
////1'b1 -> Enable  Mission Error Reporting for ECC DED Error from on-chip SRAM/Fifo from <NV_DLA>.<CACC>.<A6BUF>
////1'b0 -> Disable Mission Error Reporting for ECC DED Error from on-chip SRAM/Fifo from <NV_DLA>.<CACC>.<A6BUF>
";
        enum ERRSLICE0_MISSIONERR_ENABLE_ERR27_enum {
            DISABLE = 1'd0;
            ENABLE = 1'd1;
        };
        field {
            encode          = ERRSLICE0_MISSIONERR_ENABLE_ERR27_enum;
            sw              = rw;
            hw              = r;
            spec_access     = rw;
            reset           = 0x1;
            reset_mask      = 0x1;
            spec_sw_default = 0x0;
            sw_default_mask = 0x0;
        } ERR27[27:27];
        ERR27->desc="
////1'b1 -> Enable  Mission Error Reporting for ECC SEC Error from on-chip SRAM/Fifo from <NV_DLA>.<CACC>.<A6BUF>
////1'b0 -> Disable Mission Error Reporting for ECC SEC Error from on-chip SRAM/Fifo from <NV_DLA>.<CACC>.<A6BUF>
";
        enum ERRSLICE0_MISSIONERR_ENABLE_ERR26_enum {
            DISABLE = 1'd0;
            ENABLE = 1'd1;
        };
        field {
            encode          = ERRSLICE0_MISSIONERR_ENABLE_ERR26_enum;
            sw              = rw;
            hw              = r;
            spec_access     = rw;
            reset           = 0x1;
            reset_mask      = 0x1;
            spec_sw_default = 0x0;
            sw_default_mask = 0x0;
        } ERR26[26:26];
        ERR26->desc="
////1'b1 -> Enable  Mission Error Reporting for ECC DED Error from on-chip SRAM/Fifo from <NV_DLA>.<CACC>.<A5BUF>
////1'b0 -> Disable Mission Error Reporting for ECC DED Error from on-chip SRAM/Fifo from <NV_DLA>.<CACC>.<A5BUF>
";
        enum ERRSLICE0_MISSIONERR_ENABLE_ERR25_enum {
            DISABLE = 1'd0;
            ENABLE = 1'd1;
        };
        field {
            encode          = ERRSLICE0_MISSIONERR_ENABLE_ERR25_enum;
            sw              = rw;
            hw              = r;
            spec_access     = rw;
            reset           = 0x1;
            reset_mask      = 0x1;
            spec_sw_default = 0x0;
            sw_default_mask = 0x0;
        } ERR25[25:25];
        ERR25->desc="
////1'b1 -> Enable  Mission Error Reporting for ECC SEC Error from on-chip SRAM/Fifo from <NV_DLA>.<CACC>.<A5BUF>
////1'b0 -> Disable Mission Error Reporting for ECC SEC Error from on-chip SRAM/Fifo from <NV_DLA>.<CACC>.<A5BUF>
";
        enum ERRSLICE0_MISSIONERR_ENABLE_ERR24_enum {
            DISABLE = 1'd0;
            ENABLE = 1'd1;
        };
        field {
            encode          = ERRSLICE0_MISSIONERR_ENABLE_ERR24_enum;
            sw              = rw;
            hw              = r;
            spec_access     = rw;
            reset           = 0x1;
            reset_mask      = 0x1;
            spec_sw_default = 0x0;
            sw_default_mask = 0x0;
        } ERR24[24:24];
        ERR24->desc="
////1'b1 -> Enable  Mission Error Reporting for ECC DED Error from on-chip SRAM/Fifo from <NV_DLA>.<CACC>.<A4BUF>
////1'b0 -> Disable Mission Error Reporting for ECC DED Error from on-chip SRAM/Fifo from <NV_DLA>.<CACC>.<A4BUF>
";
        enum ERRSLICE0_MISSIONERR_ENABLE_ERR23_enum {
            DISABLE = 1'd0;
            ENABLE = 1'd1;
        };
        field {
            encode          = ERRSLICE0_MISSIONERR_ENABLE_ERR23_enum;
            sw              = rw;
            hw              = r;
            spec_access     = rw;
            reset           = 0x1;
            reset_mask      = 0x1;
            spec_sw_default = 0x0;
            sw_default_mask = 0x0;
        } ERR23[23:23];
        ERR23->desc="
////1'b1 -> Enable  Mission Error Reporting for ECC SEC Error from on-chip SRAM/Fifo from <NV_DLA>.<CACC>.<A4BUF>
////1'b0 -> Disable Mission Error Reporting for ECC SEC Error from on-chip SRAM/Fifo from <NV_DLA>.<CACC>.<A4BUF>
";
        enum ERRSLICE0_MISSIONERR_ENABLE_ERR22_enum {
            DISABLE = 1'd0;
            ENABLE = 1'd1;
        };
        field {
            encode          = ERRSLICE0_MISSIONERR_ENABLE_ERR22_enum;
            sw              = rw;
            hw              = r;
            spec_access     = rw;
            reset           = 0x1;
            reset_mask      = 0x1;
            spec_sw_default = 0x0;
            sw_default_mask = 0x0;
        } ERR22[22:22];
        ERR22->desc="
////1'b1 -> Enable  Mission Error Reporting for ECC DED Error from on-chip SRAM/Fifo from <NV_DLA>.<CACC>.<A3BUF>
////1'b0 -> Disable Mission Error Reporting for ECC DED Error from on-chip SRAM/Fifo from <NV_DLA>.<CACC>.<A3BUF>
";
        enum ERRSLICE0_MISSIONERR_ENABLE_ERR21_enum {
            DISABLE = 1'd0;
            ENABLE = 1'd1;
        };
        field {
            encode          = ERRSLICE0_MISSIONERR_ENABLE_ERR21_enum;
            sw              = rw;
            hw              = r;
            spec_access     = rw;
            reset           = 0x1;
            reset_mask      = 0x1;
            spec_sw_default = 0x0;
            sw_default_mask = 0x0;
        } ERR21[21:21];
        ERR21->desc="
////1'b1 -> Enable  Mission Error Reporting for ECC SEC Error from on-chip SRAM/Fifo from <NV_DLA>.<CACC>.<A3BUF>
////1'b0 -> Disable Mission Error Reporting for ECC SEC Error from on-chip SRAM/Fifo from <NV_DLA>.<CACC>.<A3BUF>
";
        enum ERRSLICE0_MISSIONERR_ENABLE_ERR20_enum {
            DISABLE = 1'd0;
            ENABLE = 1'd1;
        };
        field {
            encode          = ERRSLICE0_MISSIONERR_ENABLE_ERR20_enum;
            sw              = rw;
            hw              = r;
            spec_access     = rw;
            reset           = 0x1;
            reset_mask      = 0x1;
            spec_sw_default = 0x0;
            sw_default_mask = 0x0;
        } ERR20[20:20];
        ERR20->desc="
////1'b1 -> Enable  Mission Error Reporting for ECC DED Error from on-chip SRAM/Fifo from <NV_DLA>.<CACC>.<A2BUF>
////1'b0 -> Disable Mission Error Reporting for ECC DED Error from on-chip SRAM/Fifo from <NV_DLA>.<CACC>.<A2BUF>
";
        enum ERRSLICE0_MISSIONERR_ENABLE_ERR19_enum {
            DISABLE = 1'd0;
            ENABLE = 1'd1;
        };
        field {
            encode          = ERRSLICE0_MISSIONERR_ENABLE_ERR19_enum;
            sw              = rw;
            hw              = r;
            spec_access     = rw;
            reset           = 0x1;
            reset_mask      = 0x1;
            spec_sw_default = 0x0;
            sw_default_mask = 0x0;
        } ERR19[19:19];
        ERR19->desc="
////1'b1 -> Enable  Mission Error Reporting for ECC SEC Error from on-chip SRAM/Fifo from <NV_DLA>.<CACC>.<A2BUF>
////1'b0 -> Disable Mission Error Reporting for ECC SEC Error from on-chip SRAM/Fifo from <NV_DLA>.<CACC>.<A2BUF>
";
        enum ERRSLICE0_MISSIONERR_ENABLE_ERR18_enum {
            DISABLE = 1'd0;
            ENABLE = 1'd1;
        };
        field {
            encode          = ERRSLICE0_MISSIONERR_ENABLE_ERR18_enum;
            sw              = rw;
            hw              = r;
            spec_access     = rw;
            reset           = 0x1;
            reset_mask      = 0x1;
            spec_sw_default = 0x0;
            sw_default_mask = 0x0;
        } ERR18[18:18];
        ERR18->desc="
////1'b1 -> Enable  Mission Error Reporting for ECC DED Error from on-chip SRAM/Fifo from <NV_DLA>.<CACC>.<A1BUF>
////1'b0 -> Disable Mission Error Reporting for ECC DED Error from on-chip SRAM/Fifo from <NV_DLA>.<CACC>.<A1BUF>
";
        enum ERRSLICE0_MISSIONERR_ENABLE_ERR17_enum {
            DISABLE = 1'd0;
            ENABLE = 1'd1;
        };
        field {
            encode          = ERRSLICE0_MISSIONERR_ENABLE_ERR17_enum;
            sw              = rw;
            hw              = r;
            spec_access     = rw;
            reset           = 0x1;
            reset_mask      = 0x1;
            spec_sw_default = 0x0;
            sw_default_mask = 0x0;
        } ERR17[17:17];
        ERR17->desc="
////1'b1 -> Enable  Mission Error Reporting for ECC SEC Error from on-chip SRAM/Fifo from <NV_DLA>.<CACC>.<A1BUF>
////1'b0 -> Disable Mission Error Reporting for ECC SEC Error from on-chip SRAM/Fifo from <NV_DLA>.<CACC>.<A1BUF>
";
        enum ERRSLICE0_MISSIONERR_ENABLE_ERR16_enum {
            DISABLE = 1'd0;
            ENABLE = 1'd1;
        };
        field {
            encode          = ERRSLICE0_MISSIONERR_ENABLE_ERR16_enum;
            sw              = rw;
            hw              = r;
            spec_access     = rw;
            reset           = 0x1;
            reset_mask      = 0x1;
            spec_sw_default = 0x0;
            sw_default_mask = 0x0;
        } ERR16[16:16];
        ERR16->desc="
////1'b1 -> Enable  Mission Error Reporting for ECC DED Error from on-chip SRAM/Fifo from <NV_DLA>.<CACC>.<A0BUF>
////1'b0 -> Disable Mission Error Reporting for ECC DED Error from on-chip SRAM/Fifo from <NV_DLA>.<CACC>.<A0BUF>
";
        enum ERRSLICE0_MISSIONERR_ENABLE_ERR15_enum {
            DISABLE = 1'd0;
            ENABLE = 1'd1;
        };
        field {
            encode          = ERRSLICE0_MISSIONERR_ENABLE_ERR15_enum;
            sw              = rw;
            hw              = r;
            spec_access     = rw;
            reset           = 0x1;
            reset_mask      = 0x1;
            spec_sw_default = 0x0;
            sw_default_mask = 0x0;
        } ERR15[15:15];
        ERR15->desc="
////1'b1 -> Enable  Mission Error Reporting for ECC SEC Error from on-chip SRAM/Fifo from <NV_DLA>.<CACC>.<A0BUF>
////1'b0 -> Disable Mission Error Reporting for ECC SEC Error from on-chip SRAM/Fifo from <NV_DLA>.<CACC>.<A0BUF>
";
        enum ERRSLICE0_MISSIONERR_ENABLE_ERR14_enum {
            DISABLE = 1'd0;
            ENABLE = 1'd1;
        };
        field {
            encode          = ERRSLICE0_MISSIONERR_ENABLE_ERR14_enum;
            sw              = rw;
            hw              = r;
            spec_access     = rw;
            reset           = 0x1;
            reset_mask      = 0x1;
            spec_sw_default = 0x0;
            sw_default_mask = 0x0;
        } ERR14[14:14];
        ERR14->desc="
////1'b1 -> Enable  Mission Error Reporting for ECC DED Error from on-chip SRAM/Fifo from <NV_DLA>.<CBUF>.<MH>
////1'b0 -> Disable Mission Error Reporting for ECC DED Error from on-chip SRAM/Fifo from <NV_DLA>.<CBUF>.<MH>
";
        enum ERRSLICE0_MISSIONERR_ENABLE_ERR13_enum {
            DISABLE = 1'd0;
            ENABLE = 1'd1;
        };
        field {
            encode          = ERRSLICE0_MISSIONERR_ENABLE_ERR13_enum;
            sw              = rw;
            hw              = r;
            spec_access     = rw;
            reset           = 0x1;
            reset_mask      = 0x1;
            spec_sw_default = 0x0;
            sw_default_mask = 0x0;
        } ERR13[13:13];
        ERR13->desc="
////1'b1 -> Enable  Mission Error Reporting for ECC SEC Error from on-chip SRAM/Fifo from <NV_DLA>.<CBUF>.<MH>
////1'b0 -> Disable Mission Error Reporting for ECC SEC Error from on-chip SRAM/Fifo from <NV_DLA>.<CBUF>.<MH>
";
        enum ERRSLICE0_MISSIONERR_ENABLE_ERR12_enum {
            DISABLE = 1'd0;
            ENABLE = 1'd1;
        };
        field {
            encode          = ERRSLICE0_MISSIONERR_ENABLE_ERR12_enum;
            sw              = rw;
            hw              = r;
            spec_access     = rw;
            reset           = 0x1;
            reset_mask      = 0x1;
            spec_sw_default = 0x0;
            sw_default_mask = 0x0;
        } ERR12[12:12];
        ERR12->desc="
////1'b1 -> Enable  Mission Error Reporting for ECC DED Error from on-chip SRAM/Fifo from <NV_DLA>.<CBUF>.<ML>
////1'b0 -> Disable Mission Error Reporting for ECC DED Error from on-chip SRAM/Fifo from <NV_DLA>.<CBUF>.<ML>
";
        enum ERRSLICE0_MISSIONERR_ENABLE_ERR11_enum {
            DISABLE = 1'd0;
            ENABLE = 1'd1;
        };
        field {
            encode          = ERRSLICE0_MISSIONERR_ENABLE_ERR11_enum;
            sw              = rw;
            hw              = r;
            spec_access     = rw;
            reset           = 0x1;
            reset_mask      = 0x1;
            spec_sw_default = 0x0;
            sw_default_mask = 0x0;
        } ERR11[11:11];
        ERR11->desc="
////1'b1 -> Enable  Mission Error Reporting for ECC SEC Error from on-chip SRAM/Fifo from <NV_DLA>.<CBUF>.<ML>
////1'b0 -> Disable Mission Error Reporting for ECC SEC Error from on-chip SRAM/Fifo from <NV_DLA>.<CBUF>.<ML>
";
        enum ERRSLICE0_MISSIONERR_ENABLE_ERR10_enum {
            DISABLE = 1'd0;
            ENABLE = 1'd1;
        };
        field {
            encode          = ERRSLICE0_MISSIONERR_ENABLE_ERR10_enum;
            sw              = rw;
            hw              = r;
            spec_access     = rw;
            reset           = 0x1;
            reset_mask      = 0x1;
            spec_sw_default = 0x0;
            sw_default_mask = 0x0;
        } ERR10[10:10];
        ERR10->desc="
////1'b1 -> Enable  Mission Error Reporting for ECC DED Error from on-chip SRAM/Fifo from <NV_DLA>.<CBUF>.<WH>
////1'b0 -> Disable Mission Error Reporting for ECC DED Error from on-chip SRAM/Fifo from <NV_DLA>.<CBUF>.<WH>
";
        enum ERRSLICE0_MISSIONERR_ENABLE_ERR9_enum {
            DISABLE = 1'd0;
            ENABLE = 1'd1;
        };
        field {
            encode          = ERRSLICE0_MISSIONERR_ENABLE_ERR9_enum;
            sw              = rw;
            hw              = r;
            spec_access     = rw;
            reset           = 0x1;
            reset_mask      = 0x1;
            spec_sw_default = 0x0;
            sw_default_mask = 0x0;
        } ERR9[9:9];
        ERR9->desc="
////1'b1 -> Enable  Mission Error Reporting for ECC SEC Error from on-chip SRAM/Fifo from <NV_DLA>.<CBUF>.<WH>
////1'b0 -> Disable Mission Error Reporting for ECC SEC Error from on-chip SRAM/Fifo from <NV_DLA>.<CBUF>.<WH>
";
        enum ERRSLICE0_MISSIONERR_ENABLE_ERR8_enum {
            DISABLE = 1'd0;
            ENABLE = 1'd1;
        };
        field {
            encode          = ERRSLICE0_MISSIONERR_ENABLE_ERR8_enum;
            sw              = rw;
            hw              = r;
            spec_access     = rw;
            reset           = 0x1;
            reset_mask      = 0x1;
            spec_sw_default = 0x0;
            sw_default_mask = 0x0;
        } ERR8[8:8];
        ERR8->desc="
////1'b1 -> Enable  Mission Error Reporting for ECC DED Error from on-chip SRAM/Fifo from <NV_DLA>.<CBUF>.<WL>
////1'b0 -> Disable Mission Error Reporting for ECC DED Error from on-chip SRAM/Fifo from <NV_DLA>.<CBUF>.<WL>
";
        enum ERRSLICE0_MISSIONERR_ENABLE_ERR7_enum {
            DISABLE = 1'd0;
            ENABLE = 1'd1;
        };
        field {
            encode          = ERRSLICE0_MISSIONERR_ENABLE_ERR7_enum;
            sw              = rw;
            hw              = r;
            spec_access     = rw;
            reset           = 0x1;
            reset_mask      = 0x1;
            spec_sw_default = 0x0;
            sw_default_mask = 0x0;
        } ERR7[7:7];
        ERR7->desc="
////1'b1 -> Enable  Mission Error Reporting for ECC SEC Error from on-chip SRAM/Fifo from <NV_DLA>.<CBUF>.<WL>
////1'b0 -> Disable Mission Error Reporting for ECC SEC Error from on-chip SRAM/Fifo from <NV_DLA>.<CBUF>.<WL>
";
        enum ERRSLICE0_MISSIONERR_ENABLE_ERR6_enum {
            DISABLE = 1'd0;
            ENABLE = 1'd1;
        };
        field {
            encode          = ERRSLICE0_MISSIONERR_ENABLE_ERR6_enum;
            sw              = rw;
            hw              = r;
            spec_access     = rw;
            reset           = 0x1;
            reset_mask      = 0x1;
            spec_sw_default = 0x0;
            sw_default_mask = 0x0;
        } ERR6[6:6];
        ERR6->desc="
////1'b1 -> Enable  Mission Error Reporting for ECC DED Error from on-chip SRAM/Fifo from <NV_DLA>.<CBUF>.<DH>
////1'b0 -> Disable Mission Error Reporting for ECC DED Error from on-chip SRAM/Fifo from <NV_DLA>.<CBUF>.<DH>
";
        enum ERRSLICE0_MISSIONERR_ENABLE_ERR5_enum {
            DISABLE = 1'd0;
            ENABLE = 1'd1;
        };
        field {
            encode          = ERRSLICE0_MISSIONERR_ENABLE_ERR5_enum;
            sw              = rw;
            hw              = r;
            spec_access     = rw;
            reset           = 0x1;
            reset_mask      = 0x1;
            spec_sw_default = 0x0;
            sw_default_mask = 0x0;
        } ERR5[5:5];
        ERR5->desc="
////1'b1 -> Enable  Mission Error Reporting for ECC SEC Error from on-chip SRAM/Fifo from <NV_DLA>.<CBUF>.<DH>
////1'b0 -> Disable Mission Error Reporting for ECC SEC Error from on-chip SRAM/Fifo from <NV_DLA>.<CBUF>.<DH>
";
        enum ERRSLICE0_MISSIONERR_ENABLE_ERR4_enum {
            DISABLE = 1'd0;
            ENABLE = 1'd1;
        };
        field {
            encode          = ERRSLICE0_MISSIONERR_ENABLE_ERR4_enum;
            sw              = rw;
            hw              = r;
            spec_access     = rw;
            reset           = 0x1;
            reset_mask      = 0x1;
            spec_sw_default = 0x0;
            sw_default_mask = 0x0;
        } ERR4[4:4];
        ERR4->desc="
////1'b1 -> Enable  Mission Error Reporting for ECC DED Error from on-chip SRAM/Fifo from <NV_DLA>.<CBUF>.<DL>
////1'b0 -> Disable Mission Error Reporting for ECC DED Error from on-chip SRAM/Fifo from <NV_DLA>.<CBUF>.<DL>
";
        enum ERRSLICE0_MISSIONERR_ENABLE_ERR3_enum {
            DISABLE = 1'd0;
            ENABLE = 1'd1;
        };
        field {
            encode          = ERRSLICE0_MISSIONERR_ENABLE_ERR3_enum;
            sw              = rw;
            hw              = r;
            spec_access     = rw;
            reset           = 0x1;
            reset_mask      = 0x1;
            spec_sw_default = 0x0;
            sw_default_mask = 0x0;
        } ERR3[3:3];
        ERR3->desc="
////1'b1 -> Enable  Mission Error Reporting for ECC SEC Error from on-chip SRAM/Fifo from <NV_DLA>.<CBUF>.<DL>
////1'b0 -> Disable Mission Error Reporting for ECC SEC Error from on-chip SRAM/Fifo from <NV_DLA>.<CBUF>.<DL>
";
        enum ERRSLICE0_MISSIONERR_ENABLE_ERR2_enum {
            DISABLE = 1'd0;
            ENABLE = 1'd1;
        };
        field {
            encode          = ERRSLICE0_MISSIONERR_ENABLE_ERR2_enum;
            sw              = rw;
            hw              = r;
            spec_access     = rw;
            reset           = 0x1;
            reset_mask      = 0x1;
            spec_sw_default = 0x0;
            sw_default_mask = 0x0;
        } ERR2[2:2];
        ERR2->desc="
////1'b1 -> Enable  Mission Error Reporting for ECC DED Error from on-chip SRAM/Fifo from <NV_DLA>.<BDMA>
////1'b0 -> Disable Mission Error Reporting for ECC DED Error from on-chip SRAM/Fifo from <NV_DLA>.<BDMA>
";
        enum ERRSLICE0_MISSIONERR_ENABLE_ERR1_enum {
            DISABLE = 1'd0;
            ENABLE = 1'd1;
        };
        field {
            encode          = ERRSLICE0_MISSIONERR_ENABLE_ERR1_enum;
            sw              = rw;
            hw              = r;
            spec_access     = rw;
            reset           = 0x1;
            reset_mask      = 0x1;
            spec_sw_default = 0x0;
            sw_default_mask = 0x0;
        } ERR1[1:1];
        ERR1->desc="
////1'b1 -> Enable  Mission Error Reporting for ECC SEC Error from on-chip SRAM/Fifo from <NV_DLA>.<BDMA>
////1'b0 -> Disable Mission Error Reporting for ECC SEC Error from on-chip SRAM/Fifo from <NV_DLA>.<BDMA>
";
        enum ERRSLICE0_MISSIONERR_ENABLE_ERR0_enum {
            DISABLE = 1'd0;
            ENABLE = 1'd1;
        };
        field {
            encode          = ERRSLICE0_MISSIONERR_ENABLE_ERR0_enum;
            sw              = rw;
            hw              = r;
            spec_access     = rw;
            reset           = 0x1;
            reset_mask      = 0x1;
            spec_sw_default = 0x0;
            sw_default_mask = 0x0;
        } ERR0[0:0];
        ERR0->desc="
////1'b1 -> Enable  Mission Error Reporting for Register Parity Error from NV_NVDLA_GLB_FC_err_collator
////1'b0 -> Disable Mission Error Reporting for Register Parity Error from NV_NVDLA_GLB_FC_err_collator
";
    }ERRSLICE0_MISSIONERR_ENABLE @0x30;
    reg {
        name = "ERRSLICE0_MISSIONERR_FORCE";
        enum ERRSLICE0_MISSIONERR_FORCE_ERR31_enum {
            NOFORCE = 1'd0;
            FORCE = 1'd1;
        };
        field {
            encode          = ERRSLICE0_MISSIONERR_FORCE_ERR31_enum;
            sw              = w;
            hw              = r;
            spec_access     = w;
            reset           = 0x0;
            reset_mask      = 0x1;
            spec_sw_default = 0x0;
            sw_default_mask = 0x0;
        } ERR31[31:31];
        ERR31->desc="
////1'b1 -> Force Assertion of Mission Error Reporting for ECC SEC Error from on-chip SRAM/Fifo from <NV_DLA>.<CACC>.<D0BUF>
////1'b0 -> Do Nothing
";
        enum ERRSLICE0_MISSIONERR_FORCE_ERR30_enum {
            NOFORCE = 1'd0;
            FORCE = 1'd1;
        };
        field {
            encode          = ERRSLICE0_MISSIONERR_FORCE_ERR30_enum;
            sw              = w;
            hw              = r;
            spec_access     = w;
            reset           = 0x0;
            reset_mask      = 0x1;
            spec_sw_default = 0x0;
            sw_default_mask = 0x0;
        } ERR30[30:30];
        ERR30->desc="
////1'b1 -> Force Assertion of Mission Error Reporting for ECC DED Error from on-chip SRAM/Fifo from <NV_DLA>.<CACC>.<A7BUF>
////1'b0 -> Do Nothing
";
        enum ERRSLICE0_MISSIONERR_FORCE_ERR29_enum {
            NOFORCE = 1'd0;
            FORCE = 1'd1;
        };
        field {
            encode          = ERRSLICE0_MISSIONERR_FORCE_ERR29_enum;
            sw              = w;
            hw              = r;
            spec_access     = w;
            reset           = 0x0;
            reset_mask      = 0x1;
            spec_sw_default = 0x0;
            sw_default_mask = 0x0;
        } ERR29[29:29];
        ERR29->desc="
////1'b1 -> Force Assertion of Mission Error Reporting for ECC SEC Error from on-chip SRAM/Fifo from <NV_DLA>.<CACC>.<A7BUF>
////1'b0 -> Do Nothing
";
        enum ERRSLICE0_MISSIONERR_FORCE_ERR28_enum {
            NOFORCE = 1'd0;
            FORCE = 1'd1;
        };
        field {
            encode          = ERRSLICE0_MISSIONERR_FORCE_ERR28_enum;
            sw              = w;
            hw              = r;
            spec_access     = w;
            reset           = 0x0;
            reset_mask      = 0x1;
            spec_sw_default = 0x0;
            sw_default_mask = 0x0;
        } ERR28[28:28];
        ERR28->desc="
////1'b1 -> Force Assertion of Mission Error Reporting for ECC DED Error from on-chip SRAM/Fifo from <NV_DLA>.<CACC>.<A6BUF>
////1'b0 -> Do Nothing
";
        enum ERRSLICE0_MISSIONERR_FORCE_ERR27_enum {
            NOFORCE = 1'd0;
            FORCE = 1'd1;
        };
        field {
            encode          = ERRSLICE0_MISSIONERR_FORCE_ERR27_enum;
            sw              = w;
            hw              = r;
            spec_access     = w;
            reset           = 0x0;
            reset_mask      = 0x1;
            spec_sw_default = 0x0;
            sw_default_mask = 0x0;
        } ERR27[27:27];
        ERR27->desc="
////1'b1 -> Force Assertion of Mission Error Reporting for ECC SEC Error from on-chip SRAM/Fifo from <NV_DLA>.<CACC>.<A6BUF>
////1'b0 -> Do Nothing
";
        enum ERRSLICE0_MISSIONERR_FORCE_ERR26_enum {
            NOFORCE = 1'd0;
            FORCE = 1'd1;
        };
        field {
            encode          = ERRSLICE0_MISSIONERR_FORCE_ERR26_enum;
            sw              = w;
            hw              = r;
            spec_access     = w;
            reset           = 0x0;
            reset_mask      = 0x1;
            spec_sw_default = 0x0;
            sw_default_mask = 0x0;
        } ERR26[26:26];
        ERR26->desc="
////1'b1 -> Force Assertion of Mission Error Reporting for ECC DED Error from on-chip SRAM/Fifo from <NV_DLA>.<CACC>.<A5BUF>
////1'b0 -> Do Nothing
";
        enum ERRSLICE0_MISSIONERR_FORCE_ERR25_enum {
            NOFORCE = 1'd0;
            FORCE = 1'd1;
        };
        field {
            encode          = ERRSLICE0_MISSIONERR_FORCE_ERR25_enum;
            sw              = w;
            hw              = r;
            spec_access     = w;
            reset           = 0x0;
            reset_mask      = 0x1;
            spec_sw_default = 0x0;
            sw_default_mask = 0x0;
        } ERR25[25:25];
        ERR25->desc="
////1'b1 -> Force Assertion of Mission Error Reporting for ECC SEC Error from on-chip SRAM/Fifo from <NV_DLA>.<CACC>.<A5BUF>
////1'b0 -> Do Nothing
";
        enum ERRSLICE0_MISSIONERR_FORCE_ERR24_enum {
            NOFORCE = 1'd0;
            FORCE = 1'd1;
        };
        field {
            encode          = ERRSLICE0_MISSIONERR_FORCE_ERR24_enum;
            sw              = w;
            hw              = r;
            spec_access     = w;
            reset           = 0x0;
            reset_mask      = 0x1;
            spec_sw_default = 0x0;
            sw_default_mask = 0x0;
        } ERR24[24:24];
        ERR24->desc="
////1'b1 -> Force Assertion of Mission Error Reporting for ECC DED Error from on-chip SRAM/Fifo from <NV_DLA>.<CACC>.<A4BUF>
////1'b0 -> Do Nothing
";
        enum ERRSLICE0_MISSIONERR_FORCE_ERR23_enum {
            NOFORCE = 1'd0;
            FORCE = 1'd1;
        };
        field {
            encode          = ERRSLICE0_MISSIONERR_FORCE_ERR23_enum;
            sw              = w;
            hw              = r;
            spec_access     = w;
            reset           = 0x0;
            reset_mask      = 0x1;
            spec_sw_default = 0x0;
            sw_default_mask = 0x0;
        } ERR23[23:23];
        ERR23->desc="
////1'b1 -> Force Assertion of Mission Error Reporting for ECC SEC Error from on-chip SRAM/Fifo from <NV_DLA>.<CACC>.<A4BUF>
////1'b0 -> Do Nothing
";
        enum ERRSLICE0_MISSIONERR_FORCE_ERR22_enum {
            NOFORCE = 1'd0;
            FORCE = 1'd1;
        };
        field {
            encode          = ERRSLICE0_MISSIONERR_FORCE_ERR22_enum;
            sw              = w;
            hw              = r;
            spec_access     = w;
            reset           = 0x0;
            reset_mask      = 0x1;
            spec_sw_default = 0x0;
            sw_default_mask = 0x0;
        } ERR22[22:22];
        ERR22->desc="
////1'b1 -> Force Assertion of Mission Error Reporting for ECC DED Error from on-chip SRAM/Fifo from <NV_DLA>.<CACC>.<A3BUF>
////1'b0 -> Do Nothing
";
        enum ERRSLICE0_MISSIONERR_FORCE_ERR21_enum {
            NOFORCE = 1'd0;
            FORCE = 1'd1;
        };
        field {
            encode          = ERRSLICE0_MISSIONERR_FORCE_ERR21_enum;
            sw              = w;
            hw              = r;
            spec_access     = w;
            reset           = 0x0;
            reset_mask      = 0x1;
            spec_sw_default = 0x0;
            sw_default_mask = 0x0;
        } ERR21[21:21];
        ERR21->desc="
////1'b1 -> Force Assertion of Mission Error Reporting for ECC SEC Error from on-chip SRAM/Fifo from <NV_DLA>.<CACC>.<A3BUF>
////1'b0 -> Do Nothing
";
        enum ERRSLICE0_MISSIONERR_FORCE_ERR20_enum {
            NOFORCE = 1'd0;
            FORCE = 1'd1;
        };
        field {
            encode          = ERRSLICE0_MISSIONERR_FORCE_ERR20_enum;
            sw              = w;
            hw              = r;
            spec_access     = w;
            reset           = 0x0;
            reset_mask      = 0x1;
            spec_sw_default = 0x0;
            sw_default_mask = 0x0;
        } ERR20[20:20];
        ERR20->desc="
////1'b1 -> Force Assertion of Mission Error Reporting for ECC DED Error from on-chip SRAM/Fifo from <NV_DLA>.<CACC>.<A2BUF>
////1'b0 -> Do Nothing
";
        enum ERRSLICE0_MISSIONERR_FORCE_ERR19_enum {
            NOFORCE = 1'd0;
            FORCE = 1'd1;
        };
        field {
            encode          = ERRSLICE0_MISSIONERR_FORCE_ERR19_enum;
            sw              = w;
            hw              = r;
            spec_access     = w;
            reset           = 0x0;
            reset_mask      = 0x1;
            spec_sw_default = 0x0;
            sw_default_mask = 0x0;
        } ERR19[19:19];
        ERR19->desc="
////1'b1 -> Force Assertion of Mission Error Reporting for ECC SEC Error from on-chip SRAM/Fifo from <NV_DLA>.<CACC>.<A2BUF>
////1'b0 -> Do Nothing
";
        enum ERRSLICE0_MISSIONERR_FORCE_ERR18_enum {
            NOFORCE = 1'd0;
            FORCE = 1'd1;
        };
        field {
            encode          = ERRSLICE0_MISSIONERR_FORCE_ERR18_enum;
            sw              = w;
            hw              = r;
            spec_access     = w;
            reset           = 0x0;
            reset_mask      = 0x1;
            spec_sw_default = 0x0;
            sw_default_mask = 0x0;
        } ERR18[18:18];
        ERR18->desc="
////1'b1 -> Force Assertion of Mission Error Reporting for ECC DED Error from on-chip SRAM/Fifo from <NV_DLA>.<CACC>.<A1BUF>
////1'b0 -> Do Nothing
";
        enum ERRSLICE0_MISSIONERR_FORCE_ERR17_enum {
            NOFORCE = 1'd0;
            FORCE = 1'd1;
        };
        field {
            encode          = ERRSLICE0_MISSIONERR_FORCE_ERR17_enum;
            sw              = w;
            hw              = r;
            spec_access     = w;
            reset           = 0x0;
            reset_mask      = 0x1;
            spec_sw_default = 0x0;
            sw_default_mask = 0x0;
        } ERR17[17:17];
        ERR17->desc="
////1'b1 -> Force Assertion of Mission Error Reporting for ECC SEC Error from on-chip SRAM/Fifo from <NV_DLA>.<CACC>.<A1BUF>
////1'b0 -> Do Nothing
";
        enum ERRSLICE0_MISSIONERR_FORCE_ERR16_enum {
            NOFORCE = 1'd0;
            FORCE = 1'd1;
        };
        field {
            encode          = ERRSLICE0_MISSIONERR_FORCE_ERR16_enum;
            sw              = w;
            hw              = r;
            spec_access     = w;
            reset           = 0x0;
            reset_mask      = 0x1;
            spec_sw_default = 0x0;
            sw_default_mask = 0x0;
        } ERR16[16:16];
        ERR16->desc="
////1'b1 -> Force Assertion of Mission Error Reporting for ECC DED Error from on-chip SRAM/Fifo from <NV_DLA>.<CACC>.<A0BUF>
////1'b0 -> Do Nothing
";
        enum ERRSLICE0_MISSIONERR_FORCE_ERR15_enum {
            NOFORCE = 1'd0;
            FORCE = 1'd1;
        };
        field {
            encode          = ERRSLICE0_MISSIONERR_FORCE_ERR15_enum;
            sw              = w;
            hw              = r;
            spec_access     = w;
            reset           = 0x0;
            reset_mask      = 0x1;
            spec_sw_default = 0x0;
            sw_default_mask = 0x0;
        } ERR15[15:15];
        ERR15->desc="
////1'b1 -> Force Assertion of Mission Error Reporting for ECC SEC Error from on-chip SRAM/Fifo from <NV_DLA>.<CACC>.<A0BUF>
////1'b0 -> Do Nothing
";
        enum ERRSLICE0_MISSIONERR_FORCE_ERR14_enum {
            NOFORCE = 1'd0;
            FORCE = 1'd1;
        };
        field {
            encode          = ERRSLICE0_MISSIONERR_FORCE_ERR14_enum;
            sw              = w;
            hw              = r;
            spec_access     = w;
            reset           = 0x0;
            reset_mask      = 0x1;
            spec_sw_default = 0x0;
            sw_default_mask = 0x0;
        } ERR14[14:14];
        ERR14->desc="
////1'b1 -> Force Assertion of Mission Error Reporting for ECC DED Error from on-chip SRAM/Fifo from <NV_DLA>.<CBUF>.<MH>
////1'b0 -> Do Nothing
";
        enum ERRSLICE0_MISSIONERR_FORCE_ERR13_enum {
            NOFORCE = 1'd0;
            FORCE = 1'd1;
        };
        field {
            encode          = ERRSLICE0_MISSIONERR_FORCE_ERR13_enum;
            sw              = w;
            hw              = r;
            spec_access     = w;
            reset           = 0x0;
            reset_mask      = 0x1;
            spec_sw_default = 0x0;
            sw_default_mask = 0x0;
        } ERR13[13:13];
        ERR13->desc="
////1'b1 -> Force Assertion of Mission Error Reporting for ECC SEC Error from on-chip SRAM/Fifo from <NV_DLA>.<CBUF>.<MH>
////1'b0 -> Do Nothing
";
        enum ERRSLICE0_MISSIONERR_FORCE_ERR12_enum {
            NOFORCE = 1'd0;
            FORCE = 1'd1;
        };
        field {
            encode          = ERRSLICE0_MISSIONERR_FORCE_ERR12_enum;
            sw              = w;
            hw              = r;
            spec_access     = w;
            reset           = 0x0;
            reset_mask      = 0x1;
            spec_sw_default = 0x0;
            sw_default_mask = 0x0;
        } ERR12[12:12];
        ERR12->desc="
////1'b1 -> Force Assertion of Mission Error Reporting for ECC DED Error from on-chip SRAM/Fifo from <NV_DLA>.<CBUF>.<ML>
////1'b0 -> Do Nothing
";
        enum ERRSLICE0_MISSIONERR_FORCE_ERR11_enum {
            NOFORCE = 1'd0;
            FORCE = 1'd1;
        };
        field {
            encode          = ERRSLICE0_MISSIONERR_FORCE_ERR11_enum;
            sw              = w;
            hw              = r;
            spec_access     = w;
            reset           = 0x0;
            reset_mask      = 0x1;
            spec_sw_default = 0x0;
            sw_default_mask = 0x0;
        } ERR11[11:11];
        ERR11->desc="
////1'b1 -> Force Assertion of Mission Error Reporting for ECC SEC Error from on-chip SRAM/Fifo from <NV_DLA>.<CBUF>.<ML>
////1'b0 -> Do Nothing
";
        enum ERRSLICE0_MISSIONERR_FORCE_ERR10_enum {
            NOFORCE = 1'd0;
            FORCE = 1'd1;
        };
        field {
            encode          = ERRSLICE0_MISSIONERR_FORCE_ERR10_enum;
            sw              = w;
            hw              = r;
            spec_access     = w;
            reset           = 0x0;
            reset_mask      = 0x1;
            spec_sw_default = 0x0;
            sw_default_mask = 0x0;
        } ERR10[10:10];
        ERR10->desc="
////1'b1 -> Force Assertion of Mission Error Reporting for ECC DED Error from on-chip SRAM/Fifo from <NV_DLA>.<CBUF>.<WH>
////1'b0 -> Do Nothing
";
        enum ERRSLICE0_MISSIONERR_FORCE_ERR9_enum {
            NOFORCE = 1'd0;
            FORCE = 1'd1;
        };
        field {
            encode          = ERRSLICE0_MISSIONERR_FORCE_ERR9_enum;
            sw              = w;
            hw              = r;
            spec_access     = w;
            reset           = 0x0;
            reset_mask      = 0x1;
            spec_sw_default = 0x0;
            sw_default_mask = 0x0;
        } ERR9[9:9];
        ERR9->desc="
////1'b1 -> Force Assertion of Mission Error Reporting for ECC SEC Error from on-chip SRAM/Fifo from <NV_DLA>.<CBUF>.<WH>
////1'b0 -> Do Nothing
";
        enum ERRSLICE0_MISSIONERR_FORCE_ERR8_enum {
            NOFORCE = 1'd0;
            FORCE = 1'd1;
        };
        field {
            encode          = ERRSLICE0_MISSIONERR_FORCE_ERR8_enum;
            sw              = w;
            hw              = r;
            spec_access     = w;
            reset           = 0x0;
            reset_mask      = 0x1;
            spec_sw_default = 0x0;
            sw_default_mask = 0x0;
        } ERR8[8:8];
        ERR8->desc="
////1'b1 -> Force Assertion of Mission Error Reporting for ECC DED Error from on-chip SRAM/Fifo from <NV_DLA>.<CBUF>.<WL>
////1'b0 -> Do Nothing
";
        enum ERRSLICE0_MISSIONERR_FORCE_ERR7_enum {
            NOFORCE = 1'd0;
            FORCE = 1'd1;
        };
        field {
            encode          = ERRSLICE0_MISSIONERR_FORCE_ERR7_enum;
            sw              = w;
            hw              = r;
            spec_access     = w;
            reset           = 0x0;
            reset_mask      = 0x1;
            spec_sw_default = 0x0;
            sw_default_mask = 0x0;
        } ERR7[7:7];
        ERR7->desc="
////1'b1 -> Force Assertion of Mission Error Reporting for ECC SEC Error from on-chip SRAM/Fifo from <NV_DLA>.<CBUF>.<WL>
////1'b0 -> Do Nothing
";
        enum ERRSLICE0_MISSIONERR_FORCE_ERR6_enum {
            NOFORCE = 1'd0;
            FORCE = 1'd1;
        };
        field {
            encode          = ERRSLICE0_MISSIONERR_FORCE_ERR6_enum;
            sw              = w;
            hw              = r;
            spec_access     = w;
            reset           = 0x0;
            reset_mask      = 0x1;
            spec_sw_default = 0x0;
            sw_default_mask = 0x0;
        } ERR6[6:6];
        ERR6->desc="
////1'b1 -> Force Assertion of Mission Error Reporting for ECC DED Error from on-chip SRAM/Fifo from <NV_DLA>.<CBUF>.<DH>
////1'b0 -> Do Nothing
";
        enum ERRSLICE0_MISSIONERR_FORCE_ERR5_enum {
            NOFORCE = 1'd0;
            FORCE = 1'd1;
        };
        field {
            encode          = ERRSLICE0_MISSIONERR_FORCE_ERR5_enum;
            sw              = w;
            hw              = r;
            spec_access     = w;
            reset           = 0x0;
            reset_mask      = 0x1;
            spec_sw_default = 0x0;
            sw_default_mask = 0x0;
        } ERR5[5:5];
        ERR5->desc="
////1'b1 -> Force Assertion of Mission Error Reporting for ECC SEC Error from on-chip SRAM/Fifo from <NV_DLA>.<CBUF>.<DH>
////1'b0 -> Do Nothing
";
        enum ERRSLICE0_MISSIONERR_FORCE_ERR4_enum {
            NOFORCE = 1'd0;
            FORCE = 1'd1;
        };
        field {
            encode          = ERRSLICE0_MISSIONERR_FORCE_ERR4_enum;
            sw              = w;
            hw              = r;
            spec_access     = w;
            reset           = 0x0;
            reset_mask      = 0x1;
            spec_sw_default = 0x0;
            sw_default_mask = 0x0;
        } ERR4[4:4];
        ERR4->desc="
////1'b1 -> Force Assertion of Mission Error Reporting for ECC DED Error from on-chip SRAM/Fifo from <NV_DLA>.<CBUF>.<DL>
////1'b0 -> Do Nothing
";
        enum ERRSLICE0_MISSIONERR_FORCE_ERR3_enum {
            NOFORCE = 1'd0;
            FORCE = 1'd1;
        };
        field {
            encode          = ERRSLICE0_MISSIONERR_FORCE_ERR3_enum;
            sw              = w;
            hw              = r;
            spec_access     = w;
            reset           = 0x0;
            reset_mask      = 0x1;
            spec_sw_default = 0x0;
            sw_default_mask = 0x0;
        } ERR3[3:3];
        ERR3->desc="
////1'b1 -> Force Assertion of Mission Error Reporting for ECC SEC Error from on-chip SRAM/Fifo from <NV_DLA>.<CBUF>.<DL>
////1'b0 -> Do Nothing
";
        enum ERRSLICE0_MISSIONERR_FORCE_ERR2_enum {
            NOFORCE = 1'd0;
            FORCE = 1'd1;
        };
        field {
            encode          = ERRSLICE0_MISSIONERR_FORCE_ERR2_enum;
            sw              = w;
            hw              = r;
            spec_access     = w;
            reset           = 0x0;
            reset_mask      = 0x1;
            spec_sw_default = 0x0;
            sw_default_mask = 0x0;
        } ERR2[2:2];
        ERR2->desc="
////1'b1 -> Force Assertion of Mission Error Reporting for ECC DED Error from on-chip SRAM/Fifo from <NV_DLA>.<BDMA>
////1'b0 -> Do Nothing
";
        enum ERRSLICE0_MISSIONERR_FORCE_ERR1_enum {
            NOFORCE = 1'd0;
            FORCE = 1'd1;
        };
        field {
            encode          = ERRSLICE0_MISSIONERR_FORCE_ERR1_enum;
            sw              = w;
            hw              = r;
            spec_access     = w;
            reset           = 0x0;
            reset_mask      = 0x1;
            spec_sw_default = 0x0;
            sw_default_mask = 0x0;
        } ERR1[1:1];
        ERR1->desc="
////1'b1 -> Force Assertion of Mission Error Reporting for ECC SEC Error from on-chip SRAM/Fifo from <NV_DLA>.<BDMA>
////1'b0 -> Do Nothing
";
        enum ERRSLICE0_MISSIONERR_FORCE_ERR0_enum {
            NOFORCE = 1'd0;
            FORCE = 1'd1;
        };
        field {
            encode          = ERRSLICE0_MISSIONERR_FORCE_ERR0_enum;
            sw              = w;
            hw              = r;
            spec_access     = w;
            reset           = 0x0;
            reset_mask      = 0x1;
            spec_sw_default = 0x0;
            sw_default_mask = 0x0;
        } ERR0[0:0];
        ERR0->desc="
////1'b1 -> Force Assertion of Mission Error Reporting for Register Parity Error from NV_NVDLA_GLB_FC_err_collator
////1'b0 -> Do Nothing
";
    }ERRSLICE0_MISSIONERR_FORCE @0x34;
    reg {
        name = "ERRSLICE0_MISSIONERR_STATUS";
        desc = "
////SW must write 1 to clear the fields of this register.
////Bits in this register continue to be logged independent of the value of MissionError_Enable register, to avoid silent dropping of errors.
";
        field {
            sw              = rw;
            hw              = r;
            spec_access     = rw;
            reset           = 0x0;
            reset_mask      = 0x1;
            spec_sw_default = 0x0;
            sw_default_mask = 0x0;
        } ERR31[31:31];
        ERR31->desc="
////1'b1 -> Error_31_pulse[1:0] for ECC SEC Error from on-chip SRAM/Fifo from <NV_DLA>.<CACC>.<D0BUF> was equal to 2'b10.
////1'b0 -> Error_31_pulse[1:0] for ECC SEC Error from on-chip SRAM/Fifo from <NV_DLA>.<CACC>.<D0BUF> was equal to 2'b01.
";
        field {
            sw              = rw;
            hw              = r;
            spec_access     = rw;
            reset           = 0x0;
            reset_mask      = 0x1;
            spec_sw_default = 0x0;
            sw_default_mask = 0x0;
        } ERR30[30:30];
        ERR30->desc="
////1'b1 -> Error_30_pulse[1:0] for ECC DED Error from on-chip SRAM/Fifo from <NV_DLA>.<CACC>.<A7BUF> was equal to 2'b10.
////1'b0 -> Error_30_pulse[1:0] for ECC DED Error from on-chip SRAM/Fifo from <NV_DLA>.<CACC>.<A7BUF> was equal to 2'b01.
";
        field {
            sw              = rw;
            hw              = r;
            spec_access     = rw;
            reset           = 0x0;
            reset_mask      = 0x1;
            spec_sw_default = 0x0;
            sw_default_mask = 0x0;
        } ERR29[29:29];
        ERR29->desc="
////1'b1 -> Error_29_pulse[1:0] for ECC SEC Error from on-chip SRAM/Fifo from <NV_DLA>.<CACC>.<A7BUF> was equal to 2'b10.
////1'b0 -> Error_29_pulse[1:0] for ECC SEC Error from on-chip SRAM/Fifo from <NV_DLA>.<CACC>.<A7BUF> was equal to 2'b01.
";
        field {
            sw              = rw;
            hw              = r;
            spec_access     = rw;
            reset           = 0x0;
            reset_mask      = 0x1;
            spec_sw_default = 0x0;
            sw_default_mask = 0x0;
        } ERR28[28:28];
        ERR28->desc="
////1'b1 -> Error_28_pulse[1:0] for ECC DED Error from on-chip SRAM/Fifo from <NV_DLA>.<CACC>.<A6BUF> was equal to 2'b10.
////1'b0 -> Error_28_pulse[1:0] for ECC DED Error from on-chip SRAM/Fifo from <NV_DLA>.<CACC>.<A6BUF> was equal to 2'b01.
";
        field {
            sw              = rw;
            hw              = r;
            spec_access     = rw;
            reset           = 0x0;
            reset_mask      = 0x1;
            spec_sw_default = 0x0;
            sw_default_mask = 0x0;
        } ERR27[27:27];
        ERR27->desc="
////1'b1 -> Error_27_pulse[1:0] for ECC SEC Error from on-chip SRAM/Fifo from <NV_DLA>.<CACC>.<A6BUF> was equal to 2'b10.
////1'b0 -> Error_27_pulse[1:0] for ECC SEC Error from on-chip SRAM/Fifo from <NV_DLA>.<CACC>.<A6BUF> was equal to 2'b01.
";
        field {
            sw              = rw;
            hw              = r;
            spec_access     = rw;
            reset           = 0x0;
            reset_mask      = 0x1;
            spec_sw_default = 0x0;
            sw_default_mask = 0x0;
        } ERR26[26:26];
        ERR26->desc="
////1'b1 -> Error_26_pulse[1:0] for ECC DED Error from on-chip SRAM/Fifo from <NV_DLA>.<CACC>.<A5BUF> was equal to 2'b10.
////1'b0 -> Error_26_pulse[1:0] for ECC DED Error from on-chip SRAM/Fifo from <NV_DLA>.<CACC>.<A5BUF> was equal to 2'b01.
";
        field {
            sw              = rw;
            hw              = r;
            spec_access     = rw;
            reset           = 0x0;
            reset_mask      = 0x1;
            spec_sw_default = 0x0;
            sw_default_mask = 0x0;
        } ERR25[25:25];
        ERR25->desc="
////1'b1 -> Error_25_pulse[1:0] for ECC SEC Error from on-chip SRAM/Fifo from <NV_DLA>.<CACC>.<A5BUF> was equal to 2'b10.
////1'b0 -> Error_25_pulse[1:0] for ECC SEC Error from on-chip SRAM/Fifo from <NV_DLA>.<CACC>.<A5BUF> was equal to 2'b01.
";
        field {
            sw              = rw;
            hw              = r;
            spec_access     = rw;
            reset           = 0x0;
            reset_mask      = 0x1;
            spec_sw_default = 0x0;
            sw_default_mask = 0x0;
        } ERR24[24:24];
        ERR24->desc="
////1'b1 -> Error_24_pulse[1:0] for ECC DED Error from on-chip SRAM/Fifo from <NV_DLA>.<CACC>.<A4BUF> was equal to 2'b10.
////1'b0 -> Error_24_pulse[1:0] for ECC DED Error from on-chip SRAM/Fifo from <NV_DLA>.<CACC>.<A4BUF> was equal to 2'b01.
";
        field {
            sw              = rw;
            hw              = r;
            spec_access     = rw;
            reset           = 0x0;
            reset_mask      = 0x1;
            spec_sw_default = 0x0;
            sw_default_mask = 0x0;
        } ERR23[23:23];
        ERR23->desc="
////1'b1 -> Error_23_pulse[1:0] for ECC SEC Error from on-chip SRAM/Fifo from <NV_DLA>.<CACC>.<A4BUF> was equal to 2'b10.
////1'b0 -> Error_23_pulse[1:0] for ECC SEC Error from on-chip SRAM/Fifo from <NV_DLA>.<CACC>.<A4BUF> was equal to 2'b01.
";
        field {
            sw              = rw;
            hw              = r;
            spec_access     = rw;
            reset           = 0x0;
            reset_mask      = 0x1;
            spec_sw_default = 0x0;
            sw_default_mask = 0x0;
        } ERR22[22:22];
        ERR22->desc="
////1'b1 -> Error_22_pulse[1:0] for ECC DED Error from on-chip SRAM/Fifo from <NV_DLA>.<CACC>.<A3BUF> was equal to 2'b10.
////1'b0 -> Error_22_pulse[1:0] for ECC DED Error from on-chip SRAM/Fifo from <NV_DLA>.<CACC>.<A3BUF> was equal to 2'b01.
";
        field {
            sw              = rw;
            hw              = r;
            spec_access     = rw;
            reset           = 0x0;
            reset_mask      = 0x1;
            spec_sw_default = 0x0;
            sw_default_mask = 0x0;
        } ERR21[21:21];
        ERR21->desc="
////1'b1 -> Error_21_pulse[1:0] for ECC SEC Error from on-chip SRAM/Fifo from <NV_DLA>.<CACC>.<A3BUF> was equal to 2'b10.
////1'b0 -> Error_21_pulse[1:0] for ECC SEC Error from on-chip SRAM/Fifo from <NV_DLA>.<CACC>.<A3BUF> was equal to 2'b01.
";
        field {
            sw              = rw;
            hw              = r;
            spec_access     = rw;
            reset           = 0x0;
            reset_mask      = 0x1;
            spec_sw_default = 0x0;
            sw_default_mask = 0x0;
        } ERR20[20:20];
        ERR20->desc="
////1'b1 -> Error_20_pulse[1:0] for ECC DED Error from on-chip SRAM/Fifo from <NV_DLA>.<CACC>.<A2BUF> was equal to 2'b10.
////1'b0 -> Error_20_pulse[1:0] for ECC DED Error from on-chip SRAM/Fifo from <NV_DLA>.<CACC>.<A2BUF> was equal to 2'b01.
";
        field {
            sw              = rw;
            hw              = r;
            spec_access     = rw;
            reset           = 0x0;
            reset_mask      = 0x1;
            spec_sw_default = 0x0;
            sw_default_mask = 0x0;
        } ERR19[19:19];
        ERR19->desc="
////1'b1 -> Error_19_pulse[1:0] for ECC SEC Error from on-chip SRAM/Fifo from <NV_DLA>.<CACC>.<A2BUF> was equal to 2'b10.
////1'b0 -> Error_19_pulse[1:0] for ECC SEC Error from on-chip SRAM/Fifo from <NV_DLA>.<CACC>.<A2BUF> was equal to 2'b01.
";
        field {
            sw              = rw;
            hw              = r;
            spec_access     = rw;
            reset           = 0x0;
            reset_mask      = 0x1;
            spec_sw_default = 0x0;
            sw_default_mask = 0x0;
        } ERR18[18:18];
        ERR18->desc="
////1'b1 -> Error_18_pulse[1:0] for ECC DED Error from on-chip SRAM/Fifo from <NV_DLA>.<CACC>.<A1BUF> was equal to 2'b10.
////1'b0 -> Error_18_pulse[1:0] for ECC DED Error from on-chip SRAM/Fifo from <NV_DLA>.<CACC>.<A1BUF> was equal to 2'b01.
";
        field {
            sw              = rw;
            hw              = r;
            spec_access     = rw;
            reset           = 0x0;
            reset_mask      = 0x1;
            spec_sw_default = 0x0;
            sw_default_mask = 0x0;
        } ERR17[17:17];
        ERR17->desc="
////1'b1 -> Error_17_pulse[1:0] for ECC SEC Error from on-chip SRAM/Fifo from <NV_DLA>.<CACC>.<A1BUF> was equal to 2'b10.
////1'b0 -> Error_17_pulse[1:0] for ECC SEC Error from on-chip SRAM/Fifo from <NV_DLA>.<CACC>.<A1BUF> was equal to 2'b01.
";
        field {
            sw              = rw;
            hw              = r;
            spec_access     = rw;
            reset           = 0x0;
            reset_mask      = 0x1;
            spec_sw_default = 0x0;
            sw_default_mask = 0x0;
        } ERR16[16:16];
        ERR16->desc="
////1'b1 -> Error_16_pulse[1:0] for ECC DED Error from on-chip SRAM/Fifo from <NV_DLA>.<CACC>.<A0BUF> was equal to 2'b10.
////1'b0 -> Error_16_pulse[1:0] for ECC DED Error from on-chip SRAM/Fifo from <NV_DLA>.<CACC>.<A0BUF> was equal to 2'b01.
";
        field {
            sw              = rw;
            hw              = r;
            spec_access     = rw;
            reset           = 0x0;
            reset_mask      = 0x1;
            spec_sw_default = 0x0;
            sw_default_mask = 0x0;
        } ERR15[15:15];
        ERR15->desc="
////1'b1 -> Error_15_pulse[1:0] for ECC SEC Error from on-chip SRAM/Fifo from <NV_DLA>.<CACC>.<A0BUF> was equal to 2'b10.
////1'b0 -> Error_15_pulse[1:0] for ECC SEC Error from on-chip SRAM/Fifo from <NV_DLA>.<CACC>.<A0BUF> was equal to 2'b01.
";
        field {
            sw              = rw;
            hw              = r;
            spec_access     = rw;
            reset           = 0x0;
            reset_mask      = 0x1;
            spec_sw_default = 0x0;
            sw_default_mask = 0x0;
        } ERR14[14:14];
        ERR14->desc="
////1'b1 -> Error_14_pulse[1:0] for ECC DED Error from on-chip SRAM/Fifo from <NV_DLA>.<CBUF>.<MH> was equal to 2'b10.
////1'b0 -> Error_14_pulse[1:0] for ECC DED Error from on-chip SRAM/Fifo from <NV_DLA>.<CBUF>.<MH> was equal to 2'b01.
";
        field {
            sw              = rw;
            hw              = r;
            spec_access     = rw;
            reset           = 0x0;
            reset_mask      = 0x1;
            spec_sw_default = 0x0;
            sw_default_mask = 0x0;
        } ERR13[13:13];
        ERR13->desc="
////1'b1 -> Error_13_pulse[1:0] for ECC SEC Error from on-chip SRAM/Fifo from <NV_DLA>.<CBUF>.<MH> was equal to 2'b10.
////1'b0 -> Error_13_pulse[1:0] for ECC SEC Error from on-chip SRAM/Fifo from <NV_DLA>.<CBUF>.<MH> was equal to 2'b01.
";
        field {
            sw              = rw;
            hw              = r;
            spec_access     = rw;
            reset           = 0x0;
            reset_mask      = 0x1;
            spec_sw_default = 0x0;
            sw_default_mask = 0x0;
        } ERR12[12:12];
        ERR12->desc="
////1'b1 -> Error_12_pulse[1:0] for ECC DED Error from on-chip SRAM/Fifo from <NV_DLA>.<CBUF>.<ML> was equal to 2'b10.
////1'b0 -> Error_12_pulse[1:0] for ECC DED Error from on-chip SRAM/Fifo from <NV_DLA>.<CBUF>.<ML> was equal to 2'b01.
";
        field {
            sw              = rw;
            hw              = r;
            spec_access     = rw;
            reset           = 0x0;
            reset_mask      = 0x1;
            spec_sw_default = 0x0;
            sw_default_mask = 0x0;
        } ERR11[11:11];
        ERR11->desc="
////1'b1 -> Error_11_pulse[1:0] for ECC SEC Error from on-chip SRAM/Fifo from <NV_DLA>.<CBUF>.<ML> was equal to 2'b10.
////1'b0 -> Error_11_pulse[1:0] for ECC SEC Error from on-chip SRAM/Fifo from <NV_DLA>.<CBUF>.<ML> was equal to 2'b01.
";
        field {
            sw              = rw;
            hw              = r;
            spec_access     = rw;
            reset           = 0x0;
            reset_mask      = 0x1;
            spec_sw_default = 0x0;
            sw_default_mask = 0x0;
        } ERR10[10:10];
        ERR10->desc="
////1'b1 -> Error_10_pulse[1:0] for ECC DED Error from on-chip SRAM/Fifo from <NV_DLA>.<CBUF>.<WH> was equal to 2'b10.
////1'b0 -> Error_10_pulse[1:0] for ECC DED Error from on-chip SRAM/Fifo from <NV_DLA>.<CBUF>.<WH> was equal to 2'b01.
";
        field {
            sw              = rw;
            hw              = r;
            spec_access     = rw;
            reset           = 0x0;
            reset_mask      = 0x1;
            spec_sw_default = 0x0;
            sw_default_mask = 0x0;
        } ERR9[9:9];
        ERR9->desc="
////1'b1 -> Error_9_pulse[1:0] for ECC SEC Error from on-chip SRAM/Fifo from <NV_DLA>.<CBUF>.<WH> was equal to 2'b10.
////1'b0 -> Error_9_pulse[1:0] for ECC SEC Error from on-chip SRAM/Fifo from <NV_DLA>.<CBUF>.<WH> was equal to 2'b01.
";
        field {
            sw              = rw;
            hw              = r;
            spec_access     = rw;
            reset           = 0x0;
            reset_mask      = 0x1;
            spec_sw_default = 0x0;
            sw_default_mask = 0x0;
        } ERR8[8:8];
        ERR8->desc="
////1'b1 -> Error_8_pulse[1:0] for ECC DED Error from on-chip SRAM/Fifo from <NV_DLA>.<CBUF>.<WL> was equal to 2'b10.
////1'b0 -> Error_8_pulse[1:0] for ECC DED Error from on-chip SRAM/Fifo from <NV_DLA>.<CBUF>.<WL> was equal to 2'b01.
";
        field {
            sw              = rw;
            hw              = r;
            spec_access     = rw;
            reset           = 0x0;
            reset_mask      = 0x1;
            spec_sw_default = 0x0;
            sw_default_mask = 0x0;
        } ERR7[7:7];
        ERR7->desc="
////1'b1 -> Error_7_pulse[1:0] for ECC SEC Error from on-chip SRAM/Fifo from <NV_DLA>.<CBUF>.<WL> was equal to 2'b10.
////1'b0 -> Error_7_pulse[1:0] for ECC SEC Error from on-chip SRAM/Fifo from <NV_DLA>.<CBUF>.<WL> was equal to 2'b01.
";
        field {
            sw              = rw;
            hw              = r;
            spec_access     = rw;
            reset           = 0x0;
            reset_mask      = 0x1;
            spec_sw_default = 0x0;
            sw_default_mask = 0x0;
        } ERR6[6:6];
        ERR6->desc="
////1'b1 -> Error_6_pulse[1:0] for ECC DED Error from on-chip SRAM/Fifo from <NV_DLA>.<CBUF>.<DH> was equal to 2'b10.
////1'b0 -> Error_6_pulse[1:0] for ECC DED Error from on-chip SRAM/Fifo from <NV_DLA>.<CBUF>.<DH> was equal to 2'b01.
";
        field {
            sw              = rw;
            hw              = r;
            spec_access     = rw;
            reset           = 0x0;
            reset_mask      = 0x1;
            spec_sw_default = 0x0;
            sw_default_mask = 0x0;
        } ERR5[5:5];
        ERR5->desc="
////1'b1 -> Error_5_pulse[1:0] for ECC SEC Error from on-chip SRAM/Fifo from <NV_DLA>.<CBUF>.<DH> was equal to 2'b10.
////1'b0 -> Error_5_pulse[1:0] for ECC SEC Error from on-chip SRAM/Fifo from <NV_DLA>.<CBUF>.<DH> was equal to 2'b01.
";
        field {
            sw              = rw;
            hw              = r;
            spec_access     = rw;
            reset           = 0x0;
            reset_mask      = 0x1;
            spec_sw_default = 0x0;
            sw_default_mask = 0x0;
        } ERR4[4:4];
        ERR4->desc="
////1'b1 -> Error_4_pulse[1:0] for ECC DED Error from on-chip SRAM/Fifo from <NV_DLA>.<CBUF>.<DL> was equal to 2'b10.
////1'b0 -> Error_4_pulse[1:0] for ECC DED Error from on-chip SRAM/Fifo from <NV_DLA>.<CBUF>.<DL> was equal to 2'b01.
";
        field {
            sw              = rw;
            hw              = r;
            spec_access     = rw;
            reset           = 0x0;
            reset_mask      = 0x1;
            spec_sw_default = 0x0;
            sw_default_mask = 0x0;
        } ERR3[3:3];
        ERR3->desc="
////1'b1 -> Error_3_pulse[1:0] for ECC SEC Error from on-chip SRAM/Fifo from <NV_DLA>.<CBUF>.<DL> was equal to 2'b10.
////1'b0 -> Error_3_pulse[1:0] for ECC SEC Error from on-chip SRAM/Fifo from <NV_DLA>.<CBUF>.<DL> was equal to 2'b01.
";
        field {
            sw              = rw;
            hw              = r;
            spec_access     = rw;
            reset           = 0x0;
            reset_mask      = 0x1;
            spec_sw_default = 0x0;
            sw_default_mask = 0x0;
        } ERR2[2:2];
        ERR2->desc="
////1'b1 -> Error_2_pulse[1:0] for ECC DED Error from on-chip SRAM/Fifo from <NV_DLA>.<BDMA> was equal to 2'b10.
////1'b0 -> Error_2_pulse[1:0] for ECC DED Error from on-chip SRAM/Fifo from <NV_DLA>.<BDMA> was equal to 2'b01.
";
        field {
            sw              = rw;
            hw              = r;
            spec_access     = rw;
            reset           = 0x0;
            reset_mask      = 0x1;
            spec_sw_default = 0x0;
            sw_default_mask = 0x0;
        } ERR1[1:1];
        ERR1->desc="
////1'b1 -> Error_1_pulse[1:0] for ECC SEC Error from on-chip SRAM/Fifo from <NV_DLA>.<BDMA> was equal to 2'b10.
////1'b0 -> Error_1_pulse[1:0] for ECC SEC Error from on-chip SRAM/Fifo from <NV_DLA>.<BDMA> was equal to 2'b01.
";
        field {
            sw              = rw;
            hw              = r;
            spec_access     = rw;
            reset           = 0x0;
            reset_mask      = 0x1;
            spec_sw_default = 0x0;
            sw_default_mask = 0x0;
        } ERR0[0:0];
        ERR0->desc="
////1'b1 -> Error_0_pulse[1:0] for Register Parity Error from NV_NVDLA_GLB_FC_err_collator was equal to 2'b10.
////1'b0 -> Error_0_pulse[1:0] for Register Parity Error from NV_NVDLA_GLB_FC_err_collator was equal to 2'b01.
";
    }ERRSLICE0_MISSIONERR_STATUS @0x38;
    reg {
        name = "ERRSLICE0_MISSIONERR_INJECT";
        enum ERRSLICE0_MISSIONERR_INJECT_ERR31_enum {
            DISABLE = 1'd0;
            ENABLE = 1'd1;
        };
        field {
            encode          = ERRSLICE0_MISSIONERR_INJECT_ERR31_enum;
            sw              = rw;
            hw              = r;
            spec_access     = rw;
            reset           = 0x0;
            reset_mask      = 0x1;
            spec_sw_default = 0x0;
            sw_default_mask = 0x0;
        } ERR31[31:31];
        ERR31->desc="
////1'b1 -> Assert the inject_error_31 output for ECC SEC Error from on-chip SRAM/Fifo to <NV_DLA>.<CACC>.<D0BUF> to allow for error injection.
////1'b0 -> De-Asseert inject_error_31 output.
";
        enum ERRSLICE0_MISSIONERR_INJECT_ERR30_enum {
            DISABLE = 1'd0;
            ENABLE = 1'd1;
        };
        field {
            encode          = ERRSLICE0_MISSIONERR_INJECT_ERR30_enum;
            sw              = rw;
            hw              = r;
            spec_access     = rw;
            reset           = 0x0;
            reset_mask      = 0x1;
            spec_sw_default = 0x0;
            sw_default_mask = 0x0;
        } ERR30[30:30];
        ERR30->desc="
////1'b1 -> Assert the inject_error_30 output for ECC DED Error from on-chip SRAM/Fifo to <NV_DLA>.<CACC>.<A7BUF> to allow for error injection.
////1'b0 -> De-Asseert inject_error_30 output.
";
        enum ERRSLICE0_MISSIONERR_INJECT_ERR29_enum {
            DISABLE = 1'd0;
            ENABLE = 1'd1;
        };
        field {
            encode          = ERRSLICE0_MISSIONERR_INJECT_ERR29_enum;
            sw              = rw;
            hw              = r;
            spec_access     = rw;
            reset           = 0x0;
            reset_mask      = 0x1;
            spec_sw_default = 0x0;
            sw_default_mask = 0x0;
        } ERR29[29:29];
        ERR29->desc="
////1'b1 -> Assert the inject_error_29 output for ECC SEC Error from on-chip SRAM/Fifo to <NV_DLA>.<CACC>.<A7BUF> to allow for error injection.
////1'b0 -> De-Asseert inject_error_29 output.
";
        enum ERRSLICE0_MISSIONERR_INJECT_ERR28_enum {
            DISABLE = 1'd0;
            ENABLE = 1'd1;
        };
        field {
            encode          = ERRSLICE0_MISSIONERR_INJECT_ERR28_enum;
            sw              = rw;
            hw              = r;
            spec_access     = rw;
            reset           = 0x0;
            reset_mask      = 0x1;
            spec_sw_default = 0x0;
            sw_default_mask = 0x0;
        } ERR28[28:28];
        ERR28->desc="
////1'b1 -> Assert the inject_error_28 output for ECC DED Error from on-chip SRAM/Fifo to <NV_DLA>.<CACC>.<A6BUF> to allow for error injection.
////1'b0 -> De-Asseert inject_error_28 output.
";
        enum ERRSLICE0_MISSIONERR_INJECT_ERR27_enum {
            DISABLE = 1'd0;
            ENABLE = 1'd1;
        };
        field {
            encode          = ERRSLICE0_MISSIONERR_INJECT_ERR27_enum;
            sw              = rw;
            hw              = r;
            spec_access     = rw;
            reset           = 0x0;
            reset_mask      = 0x1;
            spec_sw_default = 0x0;
            sw_default_mask = 0x0;
        } ERR27[27:27];
        ERR27->desc="
////1'b1 -> Assert the inject_error_27 output for ECC SEC Error from on-chip SRAM/Fifo to <NV_DLA>.<CACC>.<A6BUF> to allow for error injection.
////1'b0 -> De-Asseert inject_error_27 output.
";
        enum ERRSLICE0_MISSIONERR_INJECT_ERR26_enum {
            DISABLE = 1'd0;
            ENABLE = 1'd1;
        };
        field {
            encode          = ERRSLICE0_MISSIONERR_INJECT_ERR26_enum;
            sw              = rw;
            hw              = r;
            spec_access     = rw;
            reset           = 0x0;
            reset_mask      = 0x1;
            spec_sw_default = 0x0;
            sw_default_mask = 0x0;
        } ERR26[26:26];
        ERR26->desc="
////1'b1 -> Assert the inject_error_26 output for ECC DED Error from on-chip SRAM/Fifo to <NV_DLA>.<CACC>.<A5BUF> to allow for error injection.
////1'b0 -> De-Asseert inject_error_26 output.
";
        enum ERRSLICE0_MISSIONERR_INJECT_ERR25_enum {
            DISABLE = 1'd0;
            ENABLE = 1'd1;
        };
        field {
            encode          = ERRSLICE0_MISSIONERR_INJECT_ERR25_enum;
            sw              = rw;
            hw              = r;
            spec_access     = rw;
            reset           = 0x0;
            reset_mask      = 0x1;
            spec_sw_default = 0x0;
            sw_default_mask = 0x0;
        } ERR25[25:25];
        ERR25->desc="
////1'b1 -> Assert the inject_error_25 output for ECC SEC Error from on-chip SRAM/Fifo to <NV_DLA>.<CACC>.<A5BUF> to allow for error injection.
////1'b0 -> De-Asseert inject_error_25 output.
";
        enum ERRSLICE0_MISSIONERR_INJECT_ERR24_enum {
            DISABLE = 1'd0;
            ENABLE = 1'd1;
        };
        field {
            encode          = ERRSLICE0_MISSIONERR_INJECT_ERR24_enum;
            sw              = rw;
            hw              = r;
            spec_access     = rw;
            reset           = 0x0;
            reset_mask      = 0x1;
            spec_sw_default = 0x0;
            sw_default_mask = 0x0;
        } ERR24[24:24];
        ERR24->desc="
////1'b1 -> Assert the inject_error_24 output for ECC DED Error from on-chip SRAM/Fifo to <NV_DLA>.<CACC>.<A4BUF> to allow for error injection.
////1'b0 -> De-Asseert inject_error_24 output.
";
        enum ERRSLICE0_MISSIONERR_INJECT_ERR23_enum {
            DISABLE = 1'd0;
            ENABLE = 1'd1;
        };
        field {
            encode          = ERRSLICE0_MISSIONERR_INJECT_ERR23_enum;
            sw              = rw;
            hw              = r;
            spec_access     = rw;
            reset           = 0x0;
            reset_mask      = 0x1;
            spec_sw_default = 0x0;
            sw_default_mask = 0x0;
        } ERR23[23:23];
        ERR23->desc="
////1'b1 -> Assert the inject_error_23 output for ECC SEC Error from on-chip SRAM/Fifo to <NV_DLA>.<CACC>.<A4BUF> to allow for error injection.
////1'b0 -> De-Asseert inject_error_23 output.
";
        enum ERRSLICE0_MISSIONERR_INJECT_ERR22_enum {
            DISABLE = 1'd0;
            ENABLE = 1'd1;
        };
        field {
            encode          = ERRSLICE0_MISSIONERR_INJECT_ERR22_enum;
            sw              = rw;
            hw              = r;
            spec_access     = rw;
            reset           = 0x0;
            reset_mask      = 0x1;
            spec_sw_default = 0x0;
            sw_default_mask = 0x0;
        } ERR22[22:22];
        ERR22->desc="
////1'b1 -> Assert the inject_error_22 output for ECC DED Error from on-chip SRAM/Fifo to <NV_DLA>.<CACC>.<A3BUF> to allow for error injection.
////1'b0 -> De-Asseert inject_error_22 output.
";
        enum ERRSLICE0_MISSIONERR_INJECT_ERR21_enum {
            DISABLE = 1'd0;
            ENABLE = 1'd1;
        };
        field {
            encode          = ERRSLICE0_MISSIONERR_INJECT_ERR21_enum;
            sw              = rw;
            hw              = r;
            spec_access     = rw;
            reset           = 0x0;
            reset_mask      = 0x1;
            spec_sw_default = 0x0;
            sw_default_mask = 0x0;
        } ERR21[21:21];
        ERR21->desc="
////1'b1 -> Assert the inject_error_21 output for ECC SEC Error from on-chip SRAM/Fifo to <NV_DLA>.<CACC>.<A3BUF> to allow for error injection.
////1'b0 -> De-Asseert inject_error_21 output.
";
        enum ERRSLICE0_MISSIONERR_INJECT_ERR20_enum {
            DISABLE = 1'd0;
            ENABLE = 1'd1;
        };
        field {
            encode          = ERRSLICE0_MISSIONERR_INJECT_ERR20_enum;
            sw              = rw;
            hw              = r;
            spec_access     = rw;
            reset           = 0x0;
            reset_mask      = 0x1;
            spec_sw_default = 0x0;
            sw_default_mask = 0x0;
        } ERR20[20:20];
        ERR20->desc="
////1'b1 -> Assert the inject_error_20 output for ECC DED Error from on-chip SRAM/Fifo to <NV_DLA>.<CACC>.<A2BUF> to allow for error injection.
////1'b0 -> De-Asseert inject_error_20 output.
";
        enum ERRSLICE0_MISSIONERR_INJECT_ERR19_enum {
            DISABLE = 1'd0;
            ENABLE = 1'd1;
        };
        field {
            encode          = ERRSLICE0_MISSIONERR_INJECT_ERR19_enum;
            sw              = rw;
            hw              = r;
            spec_access     = rw;
            reset           = 0x0;
            reset_mask      = 0x1;
            spec_sw_default = 0x0;
            sw_default_mask = 0x0;
        } ERR19[19:19];
        ERR19->desc="
////1'b1 -> Assert the inject_error_19 output for ECC SEC Error from on-chip SRAM/Fifo to <NV_DLA>.<CACC>.<A2BUF> to allow for error injection.
////1'b0 -> De-Asseert inject_error_19 output.
";
        enum ERRSLICE0_MISSIONERR_INJECT_ERR18_enum {
            DISABLE = 1'd0;
            ENABLE = 1'd1;
        };
        field {
            encode          = ERRSLICE0_MISSIONERR_INJECT_ERR18_enum;
            sw              = rw;
            hw              = r;
            spec_access     = rw;
            reset           = 0x0;
            reset_mask      = 0x1;
            spec_sw_default = 0x0;
            sw_default_mask = 0x0;
        } ERR18[18:18];
        ERR18->desc="
////1'b1 -> Assert the inject_error_18 output for ECC DED Error from on-chip SRAM/Fifo to <NV_DLA>.<CACC>.<A1BUF> to allow for error injection.
////1'b0 -> De-Asseert inject_error_18 output.
";
        enum ERRSLICE0_MISSIONERR_INJECT_ERR17_enum {
            DISABLE = 1'd0;
            ENABLE = 1'd1;
        };
        field {
            encode          = ERRSLICE0_MISSIONERR_INJECT_ERR17_enum;
            sw              = rw;
            hw              = r;
            spec_access     = rw;
            reset           = 0x0;
            reset_mask      = 0x1;
            spec_sw_default = 0x0;
            sw_default_mask = 0x0;
        } ERR17[17:17];
        ERR17->desc="
////1'b1 -> Assert the inject_error_17 output for ECC SEC Error from on-chip SRAM/Fifo to <NV_DLA>.<CACC>.<A1BUF> to allow for error injection.
////1'b0 -> De-Asseert inject_error_17 output.
";
        enum ERRSLICE0_MISSIONERR_INJECT_ERR16_enum {
            DISABLE = 1'd0;
            ENABLE = 1'd1;
        };
        field {
            encode          = ERRSLICE0_MISSIONERR_INJECT_ERR16_enum;
            sw              = rw;
            hw              = r;
            spec_access     = rw;
            reset           = 0x0;
            reset_mask      = 0x1;
            spec_sw_default = 0x0;
            sw_default_mask = 0x0;
        } ERR16[16:16];
        ERR16->desc="
////1'b1 -> Assert the inject_error_16 output for ECC DED Error from on-chip SRAM/Fifo to <NV_DLA>.<CACC>.<A0BUF> to allow for error injection.
////1'b0 -> De-Asseert inject_error_16 output.
";
        enum ERRSLICE0_MISSIONERR_INJECT_ERR15_enum {
            DISABLE = 1'd0;
            ENABLE = 1'd1;
        };
        field {
            encode          = ERRSLICE0_MISSIONERR_INJECT_ERR15_enum;
            sw              = rw;
            hw              = r;
            spec_access     = rw;
            reset           = 0x0;
            reset_mask      = 0x1;
            spec_sw_default = 0x0;
            sw_default_mask = 0x0;
        } ERR15[15:15];
        ERR15->desc="
////1'b1 -> Assert the inject_error_15 output for ECC SEC Error from on-chip SRAM/Fifo to <NV_DLA>.<CACC>.<A0BUF> to allow for error injection.
////1'b0 -> De-Asseert inject_error_15 output.
";
        enum ERRSLICE0_MISSIONERR_INJECT_ERR8_enum {
            DISABLE = 1'd0;
            ENABLE = 1'd1;
        };
        field {
            encode          = ERRSLICE0_MISSIONERR_INJECT_ERR8_enum;
            sw              = rw;
            hw              = r;
            spec_access     = rw;
            reset           = 0x0;
            reset_mask      = 0x1;
            spec_sw_default = 0x0;
            sw_default_mask = 0x0;
        } ERR8[8:8];
        ERR8->desc="
////1'b1 -> Assert the inject_error_8 output for ECC DED Error from on-chip SRAM/Fifo to <NV_DLA>.<CBUF>.<WL> to allow for error injection.
////1'b0 -> De-Asseert inject_error_8 output.
";
        enum ERRSLICE0_MISSIONERR_INJECT_ERR7_enum {
            DISABLE = 1'd0;
            ENABLE = 1'd1;
        };
        field {
            encode          = ERRSLICE0_MISSIONERR_INJECT_ERR7_enum;
            sw              = rw;
            hw              = r;
            spec_access     = rw;
            reset           = 0x0;
            reset_mask      = 0x1;
            spec_sw_default = 0x0;
            sw_default_mask = 0x0;
        } ERR7[7:7];
        ERR7->desc="
////1'b1 -> Assert the inject_error_7 output for ECC SEC Error from on-chip SRAM/Fifo to <NV_DLA>.<CBUF>.<WL> to allow for error injection.
////1'b0 -> De-Asseert inject_error_7 output.
";
        enum ERRSLICE0_MISSIONERR_INJECT_ERR6_enum {
            DISABLE = 1'd0;
            ENABLE = 1'd1;
        };
        field {
            encode          = ERRSLICE0_MISSIONERR_INJECT_ERR6_enum;
            sw              = rw;
            hw              = r;
            spec_access     = rw;
            reset           = 0x0;
            reset_mask      = 0x1;
            spec_sw_default = 0x0;
            sw_default_mask = 0x0;
        } ERR6[6:6];
        ERR6->desc="
////1'b1 -> Assert the inject_error_6 output for ECC DED Error from on-chip SRAM/Fifo to <NV_DLA>.<CBUF>.<DH> to allow for error injection.
////1'b0 -> De-Asseert inject_error_6 output.
";
        enum ERRSLICE0_MISSIONERR_INJECT_ERR5_enum {
            DISABLE = 1'd0;
            ENABLE = 1'd1;
        };
        field {
            encode          = ERRSLICE0_MISSIONERR_INJECT_ERR5_enum;
            sw              = rw;
            hw              = r;
            spec_access     = rw;
            reset           = 0x0;
            reset_mask      = 0x1;
            spec_sw_default = 0x0;
            sw_default_mask = 0x0;
        } ERR5[5:5];
        ERR5->desc="
////1'b1 -> Assert the inject_error_5 output for ECC SEC Error from on-chip SRAM/Fifo to <NV_DLA>.<CBUF>.<DH> to allow for error injection.
////1'b0 -> De-Asseert inject_error_5 output.
";
        enum ERRSLICE0_MISSIONERR_INJECT_ERR4_enum {
            DISABLE = 1'd0;
            ENABLE = 1'd1;
        };
        field {
            encode          = ERRSLICE0_MISSIONERR_INJECT_ERR4_enum;
            sw              = rw;
            hw              = r;
            spec_access     = rw;
            reset           = 0x0;
            reset_mask      = 0x1;
            spec_sw_default = 0x0;
            sw_default_mask = 0x0;
        } ERR4[4:4];
        ERR4->desc="
////1'b1 -> Assert the inject_error_4 output for ECC DED Error from on-chip SRAM/Fifo to <NV_DLA>.<CBUF>.<DL> to allow for error injection.
////1'b0 -> De-Asseert inject_error_4 output.
";
        enum ERRSLICE0_MISSIONERR_INJECT_ERR3_enum {
            DISABLE = 1'd0;
            ENABLE = 1'd1;
        };
        field {
            encode          = ERRSLICE0_MISSIONERR_INJECT_ERR3_enum;
            sw              = rw;
            hw              = r;
            spec_access     = rw;
            reset           = 0x0;
            reset_mask      = 0x1;
            spec_sw_default = 0x0;
            sw_default_mask = 0x0;
        } ERR3[3:3];
        ERR3->desc="
////1'b1 -> Assert the inject_error_3 output for ECC SEC Error from on-chip SRAM/Fifo to <NV_DLA>.<CBUF>.<DL> to allow for error injection.
////1'b0 -> De-Asseert inject_error_3 output.
";
        enum ERRSLICE0_MISSIONERR_INJECT_ERR2_enum {
            DISABLE = 1'd0;
            ENABLE = 1'd1;
        };
        field {
            encode          = ERRSLICE0_MISSIONERR_INJECT_ERR2_enum;
            sw              = rw;
            hw              = r;
            spec_access     = rw;
            reset           = 0x0;
            reset_mask      = 0x1;
            spec_sw_default = 0x0;
            sw_default_mask = 0x0;
        } ERR2[2:2];
        ERR2->desc="
////1'b1 -> Assert the inject_error_2 output for ECC DED Error from on-chip SRAM/Fifo to <NV_DLA>.<BDMA> to allow for error injection.
////1'b0 -> De-Asseert inject_error_2 output.
";
        enum ERRSLICE0_MISSIONERR_INJECT_ERR1_enum {
            DISABLE = 1'd0;
            ENABLE = 1'd1;
        };
        field {
            encode          = ERRSLICE0_MISSIONERR_INJECT_ERR1_enum;
            sw              = rw;
            hw              = r;
            spec_access     = rw;
            reset           = 0x0;
            reset_mask      = 0x1;
            spec_sw_default = 0x0;
            sw_default_mask = 0x0;
        } ERR1[1:1];
        ERR1->desc="
////1'b1 -> Assert the inject_error_1 output for ECC SEC Error from on-chip SRAM/Fifo to <NV_DLA>.<BDMA> to allow for error injection.
////1'b0 -> De-Asseert inject_error_1 output.
";
        enum ERRSLICE0_MISSIONERR_INJECT_ERR0_enum {
            DISABLE = 1'd0;
            ENABLE = 1'd1;
        };
        field {
            encode          = ERRSLICE0_MISSIONERR_INJECT_ERR0_enum;
            sw              = rw;
            hw              = r;
            spec_access     = rw;
            reset           = 0x0;
            reset_mask      = 0x1;
            spec_sw_default = 0x0;
            sw_default_mask = 0x0;
        } ERR0[0:0];
        ERR0->desc="
////1'b1 -> Assert the inject_error_0 output for Register Parity Error to NV_NVDLA_GLB_FC_err_collator to allow for error injection.
////1'b0 -> De-Asseert inject_error_0 output.
";
    }ERRSLICE0_MISSIONERR_INJECT @0x3c;
    reg {
        name = "ERRSLICE0_LATENTERR_ENABLE";
        enum ERRSLICE0_LATENTERR_ENABLE_ERR31_enum {
            DISABLE = 1'd0;
            ENABLE = 1'd1;
        };
        field {
            encode          = ERRSLICE0_LATENTERR_ENABLE_ERR31_enum;
            sw              = rw;
            hw              = r;
            spec_access     = rw;
            reset           = 0x1;
            reset_mask      = 0x1;
            spec_sw_default = 0x0;
            sw_default_mask = 0x0;
        } ERR31[31:31];
        ERR31->desc="
////1'b1 -> Enable  Latent Error Reporting for ECC SEC Error from on-chip SRAM/Fifo from <NV_DLA>.<CACC>.<D0BUF>
////1'b0 -> Disable Latent Error Reporting for ECC SEC Error from on-chip SRAM/Fifo from <NV_DLA>.<CACC>.<D0BUF>
";
        enum ERRSLICE0_LATENTERR_ENABLE_ERR30_enum {
            DISABLE = 1'd0;
            ENABLE = 1'd1;
        };
        field {
            encode          = ERRSLICE0_LATENTERR_ENABLE_ERR30_enum;
            sw              = rw;
            hw              = r;
            spec_access     = rw;
            reset           = 0x1;
            reset_mask      = 0x1;
            spec_sw_default = 0x0;
            sw_default_mask = 0x0;
        } ERR30[30:30];
        ERR30->desc="
////1'b1 -> Enable  Latent Error Reporting for ECC DED Error from on-chip SRAM/Fifo from <NV_DLA>.<CACC>.<A7BUF>
////1'b0 -> Disable Latent Error Reporting for ECC DED Error from on-chip SRAM/Fifo from <NV_DLA>.<CACC>.<A7BUF>
";
        enum ERRSLICE0_LATENTERR_ENABLE_ERR29_enum {
            DISABLE = 1'd0;
            ENABLE = 1'd1;
        };
        field {
            encode          = ERRSLICE0_LATENTERR_ENABLE_ERR29_enum;
            sw              = rw;
            hw              = r;
            spec_access     = rw;
            reset           = 0x1;
            reset_mask      = 0x1;
            spec_sw_default = 0x0;
            sw_default_mask = 0x0;
        } ERR29[29:29];
        ERR29->desc="
////1'b1 -> Enable  Latent Error Reporting for ECC SEC Error from on-chip SRAM/Fifo from <NV_DLA>.<CACC>.<A7BUF>
////1'b0 -> Disable Latent Error Reporting for ECC SEC Error from on-chip SRAM/Fifo from <NV_DLA>.<CACC>.<A7BUF>
";
        enum ERRSLICE0_LATENTERR_ENABLE_ERR28_enum {
            DISABLE = 1'd0;
            ENABLE = 1'd1;
        };
        field {
            encode          = ERRSLICE0_LATENTERR_ENABLE_ERR28_enum;
            sw              = rw;
            hw              = r;
            spec_access     = rw;
            reset           = 0x1;
            reset_mask      = 0x1;
            spec_sw_default = 0x0;
            sw_default_mask = 0x0;
        } ERR28[28:28];
        ERR28->desc="
////1'b1 -> Enable  Latent Error Reporting for ECC DED Error from on-chip SRAM/Fifo from <NV_DLA>.<CACC>.<A6BUF>
////1'b0 -> Disable Latent Error Reporting for ECC DED Error from on-chip SRAM/Fifo from <NV_DLA>.<CACC>.<A6BUF>
";
        enum ERRSLICE0_LATENTERR_ENABLE_ERR27_enum {
            DISABLE = 1'd0;
            ENABLE = 1'd1;
        };
        field {
            encode          = ERRSLICE0_LATENTERR_ENABLE_ERR27_enum;
            sw              = rw;
            hw              = r;
            spec_access     = rw;
            reset           = 0x1;
            reset_mask      = 0x1;
            spec_sw_default = 0x0;
            sw_default_mask = 0x0;
        } ERR27[27:27];
        ERR27->desc="
////1'b1 -> Enable  Latent Error Reporting for ECC SEC Error from on-chip SRAM/Fifo from <NV_DLA>.<CACC>.<A6BUF>
////1'b0 -> Disable Latent Error Reporting for ECC SEC Error from on-chip SRAM/Fifo from <NV_DLA>.<CACC>.<A6BUF>
";
        enum ERRSLICE0_LATENTERR_ENABLE_ERR26_enum {
            DISABLE = 1'd0;
            ENABLE = 1'd1;
        };
        field {
            encode          = ERRSLICE0_LATENTERR_ENABLE_ERR26_enum;
            sw              = rw;
            hw              = r;
            spec_access     = rw;
            reset           = 0x1;
            reset_mask      = 0x1;
            spec_sw_default = 0x0;
            sw_default_mask = 0x0;
        } ERR26[26:26];
        ERR26->desc="
////1'b1 -> Enable  Latent Error Reporting for ECC DED Error from on-chip SRAM/Fifo from <NV_DLA>.<CACC>.<A5BUF>
////1'b0 -> Disable Latent Error Reporting for ECC DED Error from on-chip SRAM/Fifo from <NV_DLA>.<CACC>.<A5BUF>
";
        enum ERRSLICE0_LATENTERR_ENABLE_ERR25_enum {
            DISABLE = 1'd0;
            ENABLE = 1'd1;
        };
        field {
            encode          = ERRSLICE0_LATENTERR_ENABLE_ERR25_enum;
            sw              = rw;
            hw              = r;
            spec_access     = rw;
            reset           = 0x1;
            reset_mask      = 0x1;
            spec_sw_default = 0x0;
            sw_default_mask = 0x0;
        } ERR25[25:25];
        ERR25->desc="
////1'b1 -> Enable  Latent Error Reporting for ECC SEC Error from on-chip SRAM/Fifo from <NV_DLA>.<CACC>.<A5BUF>
////1'b0 -> Disable Latent Error Reporting for ECC SEC Error from on-chip SRAM/Fifo from <NV_DLA>.<CACC>.<A5BUF>
";
        enum ERRSLICE0_LATENTERR_ENABLE_ERR24_enum {
            DISABLE = 1'd0;
            ENABLE = 1'd1;
        };
        field {
            encode          = ERRSLICE0_LATENTERR_ENABLE_ERR24_enum;
            sw              = rw;
            hw              = r;
            spec_access     = rw;
            reset           = 0x1;
            reset_mask      = 0x1;
            spec_sw_default = 0x0;
            sw_default_mask = 0x0;
        } ERR24[24:24];
        ERR24->desc="
////1'b1 -> Enable  Latent Error Reporting for ECC DED Error from on-chip SRAM/Fifo from <NV_DLA>.<CACC>.<A4BUF>
////1'b0 -> Disable Latent Error Reporting for ECC DED Error from on-chip SRAM/Fifo from <NV_DLA>.<CACC>.<A4BUF>
";
        enum ERRSLICE0_LATENTERR_ENABLE_ERR23_enum {
            DISABLE = 1'd0;
            ENABLE = 1'd1;
        };
        field {
            encode          = ERRSLICE0_LATENTERR_ENABLE_ERR23_enum;
            sw              = rw;
            hw              = r;
            spec_access     = rw;
            reset           = 0x1;
            reset_mask      = 0x1;
            spec_sw_default = 0x0;
            sw_default_mask = 0x0;
        } ERR23[23:23];
        ERR23->desc="
////1'b1 -> Enable  Latent Error Reporting for ECC SEC Error from on-chip SRAM/Fifo from <NV_DLA>.<CACC>.<A4BUF>
////1'b0 -> Disable Latent Error Reporting for ECC SEC Error from on-chip SRAM/Fifo from <NV_DLA>.<CACC>.<A4BUF>
";
        enum ERRSLICE0_LATENTERR_ENABLE_ERR22_enum {
            DISABLE = 1'd0;
            ENABLE = 1'd1;
        };
        field {
            encode          = ERRSLICE0_LATENTERR_ENABLE_ERR22_enum;
            sw              = rw;
            hw              = r;
            spec_access     = rw;
            reset           = 0x1;
            reset_mask      = 0x1;
            spec_sw_default = 0x0;
            sw_default_mask = 0x0;
        } ERR22[22:22];
        ERR22->desc="
////1'b1 -> Enable  Latent Error Reporting for ECC DED Error from on-chip SRAM/Fifo from <NV_DLA>.<CACC>.<A3BUF>
////1'b0 -> Disable Latent Error Reporting for ECC DED Error from on-chip SRAM/Fifo from <NV_DLA>.<CACC>.<A3BUF>
";
        enum ERRSLICE0_LATENTERR_ENABLE_ERR21_enum {
            DISABLE = 1'd0;
            ENABLE = 1'd1;
        };
        field {
            encode          = ERRSLICE0_LATENTERR_ENABLE_ERR21_enum;
            sw              = rw;
            hw              = r;
            spec_access     = rw;
            reset           = 0x1;
            reset_mask      = 0x1;
            spec_sw_default = 0x0;
            sw_default_mask = 0x0;
        } ERR21[21:21];
        ERR21->desc="
////1'b1 -> Enable  Latent Error Reporting for ECC SEC Error from on-chip SRAM/Fifo from <NV_DLA>.<CACC>.<A3BUF>
////1'b0 -> Disable Latent Error Reporting for ECC SEC Error from on-chip SRAM/Fifo from <NV_DLA>.<CACC>.<A3BUF>
";
        enum ERRSLICE0_LATENTERR_ENABLE_ERR20_enum {
            DISABLE = 1'd0;
            ENABLE = 1'd1;
        };
        field {
            encode          = ERRSLICE0_LATENTERR_ENABLE_ERR20_enum;
            sw              = rw;
            hw              = r;
            spec_access     = rw;
            reset           = 0x1;
            reset_mask      = 0x1;
            spec_sw_default = 0x0;
            sw_default_mask = 0x0;
        } ERR20[20:20];
        ERR20->desc="
////1'b1 -> Enable  Latent Error Reporting for ECC DED Error from on-chip SRAM/Fifo from <NV_DLA>.<CACC>.<A2BUF>
////1'b0 -> Disable Latent Error Reporting for ECC DED Error from on-chip SRAM/Fifo from <NV_DLA>.<CACC>.<A2BUF>
";
        enum ERRSLICE0_LATENTERR_ENABLE_ERR19_enum {
            DISABLE = 1'd0;
            ENABLE = 1'd1;
        };
        field {
            encode          = ERRSLICE0_LATENTERR_ENABLE_ERR19_enum;
            sw              = rw;
            hw              = r;
            spec_access     = rw;
            reset           = 0x1;
            reset_mask      = 0x1;
            spec_sw_default = 0x0;
            sw_default_mask = 0x0;
        } ERR19[19:19];
        ERR19->desc="
////1'b1 -> Enable  Latent Error Reporting for ECC SEC Error from on-chip SRAM/Fifo from <NV_DLA>.<CACC>.<A2BUF>
////1'b0 -> Disable Latent Error Reporting for ECC SEC Error from on-chip SRAM/Fifo from <NV_DLA>.<CACC>.<A2BUF>
";
        enum ERRSLICE0_LATENTERR_ENABLE_ERR18_enum {
            DISABLE = 1'd0;
            ENABLE = 1'd1;
        };
        field {
            encode          = ERRSLICE0_LATENTERR_ENABLE_ERR18_enum;
            sw              = rw;
            hw              = r;
            spec_access     = rw;
            reset           = 0x1;
            reset_mask      = 0x1;
            spec_sw_default = 0x0;
            sw_default_mask = 0x0;
        } ERR18[18:18];
        ERR18->desc="
////1'b1 -> Enable  Latent Error Reporting for ECC DED Error from on-chip SRAM/Fifo from <NV_DLA>.<CACC>.<A1BUF>
////1'b0 -> Disable Latent Error Reporting for ECC DED Error from on-chip SRAM/Fifo from <NV_DLA>.<CACC>.<A1BUF>
";
        enum ERRSLICE0_LATENTERR_ENABLE_ERR17_enum {
            DISABLE = 1'd0;
            ENABLE = 1'd1;
        };
        field {
            encode          = ERRSLICE0_LATENTERR_ENABLE_ERR17_enum;
            sw              = rw;
            hw              = r;
            spec_access     = rw;
            reset           = 0x1;
            reset_mask      = 0x1;
            spec_sw_default = 0x0;
            sw_default_mask = 0x0;
        } ERR17[17:17];
        ERR17->desc="
////1'b1 -> Enable  Latent Error Reporting for ECC SEC Error from on-chip SRAM/Fifo from <NV_DLA>.<CACC>.<A1BUF>
////1'b0 -> Disable Latent Error Reporting for ECC SEC Error from on-chip SRAM/Fifo from <NV_DLA>.<CACC>.<A1BUF>
";
        enum ERRSLICE0_LATENTERR_ENABLE_ERR16_enum {
            DISABLE = 1'd0;
            ENABLE = 1'd1;
        };
        field {
            encode          = ERRSLICE0_LATENTERR_ENABLE_ERR16_enum;
            sw              = rw;
            hw              = r;
            spec_access     = rw;
            reset           = 0x1;
            reset_mask      = 0x1;
            spec_sw_default = 0x0;
            sw_default_mask = 0x0;
        } ERR16[16:16];
        ERR16->desc="
////1'b1 -> Enable  Latent Error Reporting for ECC DED Error from on-chip SRAM/Fifo from <NV_DLA>.<CACC>.<A0BUF>
////1'b0 -> Disable Latent Error Reporting for ECC DED Error from on-chip SRAM/Fifo from <NV_DLA>.<CACC>.<A0BUF>
";
        enum ERRSLICE0_LATENTERR_ENABLE_ERR15_enum {
            DISABLE = 1'd0;
            ENABLE = 1'd1;
        };
        field {
            encode          = ERRSLICE0_LATENTERR_ENABLE_ERR15_enum;
            sw              = rw;
            hw              = r;
            spec_access     = rw;
            reset           = 0x1;
            reset_mask      = 0x1;
            spec_sw_default = 0x0;
            sw_default_mask = 0x0;
        } ERR15[15:15];
        ERR15->desc="
////1'b1 -> Enable  Latent Error Reporting for ECC SEC Error from on-chip SRAM/Fifo from <NV_DLA>.<CACC>.<A0BUF>
////1'b0 -> Disable Latent Error Reporting for ECC SEC Error from on-chip SRAM/Fifo from <NV_DLA>.<CACC>.<A0BUF>
";
        enum ERRSLICE0_LATENTERR_ENABLE_ERR14_enum {
            DISABLE = 1'd0;
            ENABLE = 1'd1;
        };
        field {
            encode          = ERRSLICE0_LATENTERR_ENABLE_ERR14_enum;
            sw              = rw;
            hw              = r;
            spec_access     = rw;
            reset           = 0x1;
            reset_mask      = 0x1;
            spec_sw_default = 0x0;
            sw_default_mask = 0x0;
        } ERR14[14:14];
        ERR14->desc="
////1'b1 -> Enable  Latent Error Reporting for ECC DED Error from on-chip SRAM/Fifo from <NV_DLA>.<CBUF>.<MH>
////1'b0 -> Disable Latent Error Reporting for ECC DED Error from on-chip SRAM/Fifo from <NV_DLA>.<CBUF>.<MH>
";
        enum ERRSLICE0_LATENTERR_ENABLE_ERR13_enum {
            DISABLE = 1'd0;
            ENABLE = 1'd1;
        };
        field {
            encode          = ERRSLICE0_LATENTERR_ENABLE_ERR13_enum;
            sw              = rw;
            hw              = r;
            spec_access     = rw;
            reset           = 0x1;
            reset_mask      = 0x1;
            spec_sw_default = 0x0;
            sw_default_mask = 0x0;
        } ERR13[13:13];
        ERR13->desc="
////1'b1 -> Enable  Latent Error Reporting for ECC SEC Error from on-chip SRAM/Fifo from <NV_DLA>.<CBUF>.<MH>
////1'b0 -> Disable Latent Error Reporting for ECC SEC Error from on-chip SRAM/Fifo from <NV_DLA>.<CBUF>.<MH>
";
        enum ERRSLICE0_LATENTERR_ENABLE_ERR12_enum {
            DISABLE = 1'd0;
            ENABLE = 1'd1;
        };
        field {
            encode          = ERRSLICE0_LATENTERR_ENABLE_ERR12_enum;
            sw              = rw;
            hw              = r;
            spec_access     = rw;
            reset           = 0x1;
            reset_mask      = 0x1;
            spec_sw_default = 0x0;
            sw_default_mask = 0x0;
        } ERR12[12:12];
        ERR12->desc="
////1'b1 -> Enable  Latent Error Reporting for ECC DED Error from on-chip SRAM/Fifo from <NV_DLA>.<CBUF>.<ML>
////1'b0 -> Disable Latent Error Reporting for ECC DED Error from on-chip SRAM/Fifo from <NV_DLA>.<CBUF>.<ML>
";
        enum ERRSLICE0_LATENTERR_ENABLE_ERR11_enum {
            DISABLE = 1'd0;
            ENABLE = 1'd1;
        };
        field {
            encode          = ERRSLICE0_LATENTERR_ENABLE_ERR11_enum;
            sw              = rw;
            hw              = r;
            spec_access     = rw;
            reset           = 0x1;
            reset_mask      = 0x1;
            spec_sw_default = 0x0;
            sw_default_mask = 0x0;
        } ERR11[11:11];
        ERR11->desc="
////1'b1 -> Enable  Latent Error Reporting for ECC SEC Error from on-chip SRAM/Fifo from <NV_DLA>.<CBUF>.<ML>
////1'b0 -> Disable Latent Error Reporting for ECC SEC Error from on-chip SRAM/Fifo from <NV_DLA>.<CBUF>.<ML>
";
        enum ERRSLICE0_LATENTERR_ENABLE_ERR10_enum {
            DISABLE = 1'd0;
            ENABLE = 1'd1;
        };
        field {
            encode          = ERRSLICE0_LATENTERR_ENABLE_ERR10_enum;
            sw              = rw;
            hw              = r;
            spec_access     = rw;
            reset           = 0x1;
            reset_mask      = 0x1;
            spec_sw_default = 0x0;
            sw_default_mask = 0x0;
        } ERR10[10:10];
        ERR10->desc="
////1'b1 -> Enable  Latent Error Reporting for ECC DED Error from on-chip SRAM/Fifo from <NV_DLA>.<CBUF>.<WH>
////1'b0 -> Disable Latent Error Reporting for ECC DED Error from on-chip SRAM/Fifo from <NV_DLA>.<CBUF>.<WH>
";
        enum ERRSLICE0_LATENTERR_ENABLE_ERR9_enum {
            DISABLE = 1'd0;
            ENABLE = 1'd1;
        };
        field {
            encode          = ERRSLICE0_LATENTERR_ENABLE_ERR9_enum;
            sw              = rw;
            hw              = r;
            spec_access     = rw;
            reset           = 0x1;
            reset_mask      = 0x1;
            spec_sw_default = 0x0;
            sw_default_mask = 0x0;
        } ERR9[9:9];
        ERR9->desc="
////1'b1 -> Enable  Latent Error Reporting for ECC SEC Error from on-chip SRAM/Fifo from <NV_DLA>.<CBUF>.<WH>
////1'b0 -> Disable Latent Error Reporting for ECC SEC Error from on-chip SRAM/Fifo from <NV_DLA>.<CBUF>.<WH>
";
        enum ERRSLICE0_LATENTERR_ENABLE_ERR8_enum {
            DISABLE = 1'd0;
            ENABLE = 1'd1;
        };
        field {
            encode          = ERRSLICE0_LATENTERR_ENABLE_ERR8_enum;
            sw              = rw;
            hw              = r;
            spec_access     = rw;
            reset           = 0x1;
            reset_mask      = 0x1;
            spec_sw_default = 0x0;
            sw_default_mask = 0x0;
        } ERR8[8:8];
        ERR8->desc="
////1'b1 -> Enable  Latent Error Reporting for ECC DED Error from on-chip SRAM/Fifo from <NV_DLA>.<CBUF>.<WL>
////1'b0 -> Disable Latent Error Reporting for ECC DED Error from on-chip SRAM/Fifo from <NV_DLA>.<CBUF>.<WL>
";
        enum ERRSLICE0_LATENTERR_ENABLE_ERR7_enum {
            DISABLE = 1'd0;
            ENABLE = 1'd1;
        };
        field {
            encode          = ERRSLICE0_LATENTERR_ENABLE_ERR7_enum;
            sw              = rw;
            hw              = r;
            spec_access     = rw;
            reset           = 0x1;
            reset_mask      = 0x1;
            spec_sw_default = 0x0;
            sw_default_mask = 0x0;
        } ERR7[7:7];
        ERR7->desc="
////1'b1 -> Enable  Latent Error Reporting for ECC SEC Error from on-chip SRAM/Fifo from <NV_DLA>.<CBUF>.<WL>
////1'b0 -> Disable Latent Error Reporting for ECC SEC Error from on-chip SRAM/Fifo from <NV_DLA>.<CBUF>.<WL>
";
        enum ERRSLICE0_LATENTERR_ENABLE_ERR6_enum {
            DISABLE = 1'd0;
            ENABLE = 1'd1;
        };
        field {
            encode          = ERRSLICE0_LATENTERR_ENABLE_ERR6_enum;
            sw              = rw;
            hw              = r;
            spec_access     = rw;
            reset           = 0x1;
            reset_mask      = 0x1;
            spec_sw_default = 0x0;
            sw_default_mask = 0x0;
        } ERR6[6:6];
        ERR6->desc="
////1'b1 -> Enable  Latent Error Reporting for ECC DED Error from on-chip SRAM/Fifo from <NV_DLA>.<CBUF>.<DH>
////1'b0 -> Disable Latent Error Reporting for ECC DED Error from on-chip SRAM/Fifo from <NV_DLA>.<CBUF>.<DH>
";
        enum ERRSLICE0_LATENTERR_ENABLE_ERR5_enum {
            DISABLE = 1'd0;
            ENABLE = 1'd1;
        };
        field {
            encode          = ERRSLICE0_LATENTERR_ENABLE_ERR5_enum;
            sw              = rw;
            hw              = r;
            spec_access     = rw;
            reset           = 0x1;
            reset_mask      = 0x1;
            spec_sw_default = 0x0;
            sw_default_mask = 0x0;
        } ERR5[5:5];
        ERR5->desc="
////1'b1 -> Enable  Latent Error Reporting for ECC SEC Error from on-chip SRAM/Fifo from <NV_DLA>.<CBUF>.<DH>
////1'b0 -> Disable Latent Error Reporting for ECC SEC Error from on-chip SRAM/Fifo from <NV_DLA>.<CBUF>.<DH>
";
        enum ERRSLICE0_LATENTERR_ENABLE_ERR4_enum {
            DISABLE = 1'd0;
            ENABLE = 1'd1;
        };
        field {
            encode          = ERRSLICE0_LATENTERR_ENABLE_ERR4_enum;
            sw              = rw;
            hw              = r;
            spec_access     = rw;
            reset           = 0x1;
            reset_mask      = 0x1;
            spec_sw_default = 0x0;
            sw_default_mask = 0x0;
        } ERR4[4:4];
        ERR4->desc="
////1'b1 -> Enable  Latent Error Reporting for ECC DED Error from on-chip SRAM/Fifo from <NV_DLA>.<CBUF>.<DL>
////1'b0 -> Disable Latent Error Reporting for ECC DED Error from on-chip SRAM/Fifo from <NV_DLA>.<CBUF>.<DL>
";
        enum ERRSLICE0_LATENTERR_ENABLE_ERR3_enum {
            DISABLE = 1'd0;
            ENABLE = 1'd1;
        };
        field {
            encode          = ERRSLICE0_LATENTERR_ENABLE_ERR3_enum;
            sw              = rw;
            hw              = r;
            spec_access     = rw;
            reset           = 0x1;
            reset_mask      = 0x1;
            spec_sw_default = 0x0;
            sw_default_mask = 0x0;
        } ERR3[3:3];
        ERR3->desc="
////1'b1 -> Enable  Latent Error Reporting for ECC SEC Error from on-chip SRAM/Fifo from <NV_DLA>.<CBUF>.<DL>
////1'b0 -> Disable Latent Error Reporting for ECC SEC Error from on-chip SRAM/Fifo from <NV_DLA>.<CBUF>.<DL>
";
        enum ERRSLICE0_LATENTERR_ENABLE_ERR2_enum {
            DISABLE = 1'd0;
            ENABLE = 1'd1;
        };
        field {
            encode          = ERRSLICE0_LATENTERR_ENABLE_ERR2_enum;
            sw              = rw;
            hw              = r;
            spec_access     = rw;
            reset           = 0x1;
            reset_mask      = 0x1;
            spec_sw_default = 0x0;
            sw_default_mask = 0x0;
        } ERR2[2:2];
        ERR2->desc="
////1'b1 -> Enable  Latent Error Reporting for ECC DED Error from on-chip SRAM/Fifo from <NV_DLA>.<BDMA>
////1'b0 -> Disable Latent Error Reporting for ECC DED Error from on-chip SRAM/Fifo from <NV_DLA>.<BDMA>
";
        enum ERRSLICE0_LATENTERR_ENABLE_ERR1_enum {
            DISABLE = 1'd0;
            ENABLE = 1'd1;
        };
        field {
            encode          = ERRSLICE0_LATENTERR_ENABLE_ERR1_enum;
            sw              = rw;
            hw              = r;
            spec_access     = rw;
            reset           = 0x1;
            reset_mask      = 0x1;
            spec_sw_default = 0x0;
            sw_default_mask = 0x0;
        } ERR1[1:1];
        ERR1->desc="
////1'b1 -> Enable  Latent Error Reporting for ECC SEC Error from on-chip SRAM/Fifo from <NV_DLA>.<BDMA>
////1'b0 -> Disable Latent Error Reporting for ECC SEC Error from on-chip SRAM/Fifo from <NV_DLA>.<BDMA>
";
        enum ERRSLICE0_LATENTERR_ENABLE_ERR0_enum {
            DISABLE = 1'd0;
            ENABLE = 1'd1;
        };
        field {
            encode          = ERRSLICE0_LATENTERR_ENABLE_ERR0_enum;
            sw              = rw;
            hw              = r;
            spec_access     = rw;
            reset           = 0x1;
            reset_mask      = 0x1;
            spec_sw_default = 0x0;
            sw_default_mask = 0x0;
        } ERR0[0:0];
        ERR0->desc="
////1'b1 -> Enable  Latent Error Reporting for Register Parity Error from NV_NVDLA_GLB_FC_err_collator
////1'b0 -> Disable Latent Error Reporting for Register Parity Error from NV_NVDLA_GLB_FC_err_collator
";
    }ERRSLICE0_LATENTERR_ENABLE @0x40;
    reg {
        name = "ERRSLICE0_LATENTERR_FORCE";
        enum ERRSLICE0_LATENTERR_FORCE_ERR31_enum {
            NOFORCE = 1'd0;
            FORCE = 1'd1;
        };
        field {
            encode          = ERRSLICE0_LATENTERR_FORCE_ERR31_enum;
            sw              = w;
            hw              = r;
            spec_access     = w;
            reset           = 0x0;
            reset_mask      = 0x1;
            spec_sw_default = 0x0;
            sw_default_mask = 0x0;
        } ERR31[31:31];
        ERR31->desc="
////1'b1 -> Force Assertion of Latent Error Reporting for ECC SEC Error from on-chip SRAM/Fifo from <NV_DLA>.<CACC>.<D0BUF>
////1'b0 -> Do Nothing
";
        enum ERRSLICE0_LATENTERR_FORCE_ERR30_enum {
            NOFORCE = 1'd0;
            FORCE = 1'd1;
        };
        field {
            encode          = ERRSLICE0_LATENTERR_FORCE_ERR30_enum;
            sw              = w;
            hw              = r;
            spec_access     = w;
            reset           = 0x0;
            reset_mask      = 0x1;
            spec_sw_default = 0x0;
            sw_default_mask = 0x0;
        } ERR30[30:30];
        ERR30->desc="
////1'b1 -> Force Assertion of Latent Error Reporting for ECC DED Error from on-chip SRAM/Fifo from <NV_DLA>.<CACC>.<A7BUF>
////1'b0 -> Do Nothing
";
        enum ERRSLICE0_LATENTERR_FORCE_ERR29_enum {
            NOFORCE = 1'd0;
            FORCE = 1'd1;
        };
        field {
            encode          = ERRSLICE0_LATENTERR_FORCE_ERR29_enum;
            sw              = w;
            hw              = r;
            spec_access     = w;
            reset           = 0x0;
            reset_mask      = 0x1;
            spec_sw_default = 0x0;
            sw_default_mask = 0x0;
        } ERR29[29:29];
        ERR29->desc="
////1'b1 -> Force Assertion of Latent Error Reporting for ECC SEC Error from on-chip SRAM/Fifo from <NV_DLA>.<CACC>.<A7BUF>
////1'b0 -> Do Nothing
";
        enum ERRSLICE0_LATENTERR_FORCE_ERR28_enum {
            NOFORCE = 1'd0;
            FORCE = 1'd1;
        };
        field {
            encode          = ERRSLICE0_LATENTERR_FORCE_ERR28_enum;
            sw              = w;
            hw              = r;
            spec_access     = w;
            reset           = 0x0;
            reset_mask      = 0x1;
            spec_sw_default = 0x0;
            sw_default_mask = 0x0;
        } ERR28[28:28];
        ERR28->desc="
////1'b1 -> Force Assertion of Latent Error Reporting for ECC DED Error from on-chip SRAM/Fifo from <NV_DLA>.<CACC>.<A6BUF>
////1'b0 -> Do Nothing
";
        enum ERRSLICE0_LATENTERR_FORCE_ERR27_enum {
            NOFORCE = 1'd0;
            FORCE = 1'd1;
        };
        field {
            encode          = ERRSLICE0_LATENTERR_FORCE_ERR27_enum;
            sw              = w;
            hw              = r;
            spec_access     = w;
            reset           = 0x0;
            reset_mask      = 0x1;
            spec_sw_default = 0x0;
            sw_default_mask = 0x0;
        } ERR27[27:27];
        ERR27->desc="
////1'b1 -> Force Assertion of Latent Error Reporting for ECC SEC Error from on-chip SRAM/Fifo from <NV_DLA>.<CACC>.<A6BUF>
////1'b0 -> Do Nothing
";
        enum ERRSLICE0_LATENTERR_FORCE_ERR26_enum {
            NOFORCE = 1'd0;
            FORCE = 1'd1;
        };
        field {
            encode          = ERRSLICE0_LATENTERR_FORCE_ERR26_enum;
            sw              = w;
            hw              = r;
            spec_access     = w;
            reset           = 0x0;
            reset_mask      = 0x1;
            spec_sw_default = 0x0;
            sw_default_mask = 0x0;
        } ERR26[26:26];
        ERR26->desc="
////1'b1 -> Force Assertion of Latent Error Reporting for ECC DED Error from on-chip SRAM/Fifo from <NV_DLA>.<CACC>.<A5BUF>
////1'b0 -> Do Nothing
";
        enum ERRSLICE0_LATENTERR_FORCE_ERR25_enum {
            NOFORCE = 1'd0;
            FORCE = 1'd1;
        };
        field {
            encode          = ERRSLICE0_LATENTERR_FORCE_ERR25_enum;
            sw              = w;
            hw              = r;
            spec_access     = w;
            reset           = 0x0;
            reset_mask      = 0x1;
            spec_sw_default = 0x0;
            sw_default_mask = 0x0;
        } ERR25[25:25];
        ERR25->desc="
////1'b1 -> Force Assertion of Latent Error Reporting for ECC SEC Error from on-chip SRAM/Fifo from <NV_DLA>.<CACC>.<A5BUF>
////1'b0 -> Do Nothing
";
        enum ERRSLICE0_LATENTERR_FORCE_ERR24_enum {
            NOFORCE = 1'd0;
            FORCE = 1'd1;
        };
        field {
            encode          = ERRSLICE0_LATENTERR_FORCE_ERR24_enum;
            sw              = w;
            hw              = r;
            spec_access     = w;
            reset           = 0x0;
            reset_mask      = 0x1;
            spec_sw_default = 0x0;
            sw_default_mask = 0x0;
        } ERR24[24:24];
        ERR24->desc="
////1'b1 -> Force Assertion of Latent Error Reporting for ECC DED Error from on-chip SRAM/Fifo from <NV_DLA>.<CACC>.<A4BUF>
////1'b0 -> Do Nothing
";
        enum ERRSLICE0_LATENTERR_FORCE_ERR23_enum {
            NOFORCE = 1'd0;
            FORCE = 1'd1;
        };
        field {
            encode          = ERRSLICE0_LATENTERR_FORCE_ERR23_enum;
            sw              = w;
            hw              = r;
            spec_access     = w;
            reset           = 0x0;
            reset_mask      = 0x1;
            spec_sw_default = 0x0;
            sw_default_mask = 0x0;
        } ERR23[23:23];
        ERR23->desc="
////1'b1 -> Force Assertion of Latent Error Reporting for ECC SEC Error from on-chip SRAM/Fifo from <NV_DLA>.<CACC>.<A4BUF>
////1'b0 -> Do Nothing
";
        enum ERRSLICE0_LATENTERR_FORCE_ERR22_enum {
            NOFORCE = 1'd0;
            FORCE = 1'd1;
        };
        field {
            encode          = ERRSLICE0_LATENTERR_FORCE_ERR22_enum;
            sw              = w;
            hw              = r;
            spec_access     = w;
            reset           = 0x0;
            reset_mask      = 0x1;
            spec_sw_default = 0x0;
            sw_default_mask = 0x0;
        } ERR22[22:22];
        ERR22->desc="
////1'b1 -> Force Assertion of Latent Error Reporting for ECC DED Error from on-chip SRAM/Fifo from <NV_DLA>.<CACC>.<A3BUF>
////1'b0 -> Do Nothing
";
        enum ERRSLICE0_LATENTERR_FORCE_ERR21_enum {
            NOFORCE = 1'd0;
            FORCE = 1'd1;
        };
        field {
            encode          = ERRSLICE0_LATENTERR_FORCE_ERR21_enum;
            sw              = w;
            hw              = r;
            spec_access     = w;
            reset           = 0x0;
            reset_mask      = 0x1;
            spec_sw_default = 0x0;
            sw_default_mask = 0x0;
        } ERR21[21:21];
        ERR21->desc="
////1'b1 -> Force Assertion of Latent Error Reporting for ECC SEC Error from on-chip SRAM/Fifo from <NV_DLA>.<CACC>.<A3BUF>
////1'b0 -> Do Nothing
";
        enum ERRSLICE0_LATENTERR_FORCE_ERR20_enum {
            NOFORCE = 1'd0;
            FORCE = 1'd1;
        };
        field {
            encode          = ERRSLICE0_LATENTERR_FORCE_ERR20_enum;
            sw              = w;
            hw              = r;
            spec_access     = w;
            reset           = 0x0;
            reset_mask      = 0x1;
            spec_sw_default = 0x0;
            sw_default_mask = 0x0;
        } ERR20[20:20];
        ERR20->desc="
////1'b1 -> Force Assertion of Latent Error Reporting for ECC DED Error from on-chip SRAM/Fifo from <NV_DLA>.<CACC>.<A2BUF>
////1'b0 -> Do Nothing
";
        enum ERRSLICE0_LATENTERR_FORCE_ERR19_enum {
            NOFORCE = 1'd0;
            FORCE = 1'd1;
        };
        field {
            encode          = ERRSLICE0_LATENTERR_FORCE_ERR19_enum;
            sw              = w;
            hw              = r;
            spec_access     = w;
            reset           = 0x0;
            reset_mask      = 0x1;
            spec_sw_default = 0x0;
            sw_default_mask = 0x0;
        } ERR19[19:19];
        ERR19->desc="
////1'b1 -> Force Assertion of Latent Error Reporting for ECC SEC Error from on-chip SRAM/Fifo from <NV_DLA>.<CACC>.<A2BUF>
////1'b0 -> Do Nothing
";
        enum ERRSLICE0_LATENTERR_FORCE_ERR18_enum {
            NOFORCE = 1'd0;
            FORCE = 1'd1;
        };
        field {
            encode          = ERRSLICE0_LATENTERR_FORCE_ERR18_enum;
            sw              = w;
            hw              = r;
            spec_access     = w;
            reset           = 0x0;
            reset_mask      = 0x1;
            spec_sw_default = 0x0;
            sw_default_mask = 0x0;
        } ERR18[18:18];
        ERR18->desc="
////1'b1 -> Force Assertion of Latent Error Reporting for ECC DED Error from on-chip SRAM/Fifo from <NV_DLA>.<CACC>.<A1BUF>
////1'b0 -> Do Nothing
";
        enum ERRSLICE0_LATENTERR_FORCE_ERR17_enum {
            NOFORCE = 1'd0;
            FORCE = 1'd1;
        };
        field {
            encode          = ERRSLICE0_LATENTERR_FORCE_ERR17_enum;
            sw              = w;
            hw              = r;
            spec_access     = w;
            reset           = 0x0;
            reset_mask      = 0x1;
            spec_sw_default = 0x0;
            sw_default_mask = 0x0;
        } ERR17[17:17];
        ERR17->desc="
////1'b1 -> Force Assertion of Latent Error Reporting for ECC SEC Error from on-chip SRAM/Fifo from <NV_DLA>.<CACC>.<A1BUF>
////1'b0 -> Do Nothing
";
        enum ERRSLICE0_LATENTERR_FORCE_ERR16_enum {
            NOFORCE = 1'd0;
            FORCE = 1'd1;
        };
        field {
            encode          = ERRSLICE0_LATENTERR_FORCE_ERR16_enum;
            sw              = w;
            hw              = r;
            spec_access     = w;
            reset           = 0x0;
            reset_mask      = 0x1;
            spec_sw_default = 0x0;
            sw_default_mask = 0x0;
        } ERR16[16:16];
        ERR16->desc="
////1'b1 -> Force Assertion of Latent Error Reporting for ECC DED Error from on-chip SRAM/Fifo from <NV_DLA>.<CACC>.<A0BUF>
////1'b0 -> Do Nothing
";
        enum ERRSLICE0_LATENTERR_FORCE_ERR15_enum {
            NOFORCE = 1'd0;
            FORCE = 1'd1;
        };
        field {
            encode          = ERRSLICE0_LATENTERR_FORCE_ERR15_enum;
            sw              = w;
            hw              = r;
            spec_access     = w;
            reset           = 0x0;
            reset_mask      = 0x1;
            spec_sw_default = 0x0;
            sw_default_mask = 0x0;
        } ERR15[15:15];
        ERR15->desc="
////1'b1 -> Force Assertion of Latent Error Reporting for ECC SEC Error from on-chip SRAM/Fifo from <NV_DLA>.<CACC>.<A0BUF>
////1'b0 -> Do Nothing
";
        enum ERRSLICE0_LATENTERR_FORCE_ERR14_enum {
            NOFORCE = 1'd0;
            FORCE = 1'd1;
        };
        field {
            encode          = ERRSLICE0_LATENTERR_FORCE_ERR14_enum;
            sw              = w;
            hw              = r;
            spec_access     = w;
            reset           = 0x0;
            reset_mask      = 0x1;
            spec_sw_default = 0x0;
            sw_default_mask = 0x0;
        } ERR14[14:14];
        ERR14->desc="
////1'b1 -> Force Assertion of Latent Error Reporting for ECC DED Error from on-chip SRAM/Fifo from <NV_DLA>.<CBUF>.<MH>
////1'b0 -> Do Nothing
";
        enum ERRSLICE0_LATENTERR_FORCE_ERR13_enum {
            NOFORCE = 1'd0;
            FORCE = 1'd1;
        };
        field {
            encode          = ERRSLICE0_LATENTERR_FORCE_ERR13_enum;
            sw              = w;
            hw              = r;
            spec_access     = w;
            reset           = 0x0;
            reset_mask      = 0x1;
            spec_sw_default = 0x0;
            sw_default_mask = 0x0;
        } ERR13[13:13];
        ERR13->desc="
////1'b1 -> Force Assertion of Latent Error Reporting for ECC SEC Error from on-chip SRAM/Fifo from <NV_DLA>.<CBUF>.<MH>
////1'b0 -> Do Nothing
";
        enum ERRSLICE0_LATENTERR_FORCE_ERR12_enum {
            NOFORCE = 1'd0;
            FORCE = 1'd1;
        };
        field {
            encode          = ERRSLICE0_LATENTERR_FORCE_ERR12_enum;
            sw              = w;
            hw              = r;
            spec_access     = w;
            reset           = 0x0;
            reset_mask      = 0x1;
            spec_sw_default = 0x0;
            sw_default_mask = 0x0;
        } ERR12[12:12];
        ERR12->desc="
////1'b1 -> Force Assertion of Latent Error Reporting for ECC DED Error from on-chip SRAM/Fifo from <NV_DLA>.<CBUF>.<ML>
////1'b0 -> Do Nothing
";
        enum ERRSLICE0_LATENTERR_FORCE_ERR11_enum {
            NOFORCE = 1'd0;
            FORCE = 1'd1;
        };
        field {
            encode          = ERRSLICE0_LATENTERR_FORCE_ERR11_enum;
            sw              = w;
            hw              = r;
            spec_access     = w;
            reset           = 0x0;
            reset_mask      = 0x1;
            spec_sw_default = 0x0;
            sw_default_mask = 0x0;
        } ERR11[11:11];
        ERR11->desc="
////1'b1 -> Force Assertion of Latent Error Reporting for ECC SEC Error from on-chip SRAM/Fifo from <NV_DLA>.<CBUF>.<ML>
////1'b0 -> Do Nothing
";
        enum ERRSLICE0_LATENTERR_FORCE_ERR10_enum {
            NOFORCE = 1'd0;
            FORCE = 1'd1;
        };
        field {
            encode          = ERRSLICE0_LATENTERR_FORCE_ERR10_enum;
            sw              = w;
            hw              = r;
            spec_access     = w;
            reset           = 0x0;
            reset_mask      = 0x1;
            spec_sw_default = 0x0;
            sw_default_mask = 0x0;
        } ERR10[10:10];
        ERR10->desc="
////1'b1 -> Force Assertion of Latent Error Reporting for ECC DED Error from on-chip SRAM/Fifo from <NV_DLA>.<CBUF>.<WH>
////1'b0 -> Do Nothing
";
        enum ERRSLICE0_LATENTERR_FORCE_ERR9_enum {
            NOFORCE = 1'd0;
            FORCE = 1'd1;
        };
        field {
            encode          = ERRSLICE0_LATENTERR_FORCE_ERR9_enum;
            sw              = w;
            hw              = r;
            spec_access     = w;
            reset           = 0x0;
            reset_mask      = 0x1;
            spec_sw_default = 0x0;
            sw_default_mask = 0x0;
        } ERR9[9:9];
        ERR9->desc="
////1'b1 -> Force Assertion of Latent Error Reporting for ECC SEC Error from on-chip SRAM/Fifo from <NV_DLA>.<CBUF>.<WH>
////1'b0 -> Do Nothing
";
        enum ERRSLICE0_LATENTERR_FORCE_ERR8_enum {
            NOFORCE = 1'd0;
            FORCE = 1'd1;
        };
        field {
            encode          = ERRSLICE0_LATENTERR_FORCE_ERR8_enum;
            sw              = w;
            hw              = r;
            spec_access     = w;
            reset           = 0x0;
            reset_mask      = 0x1;
            spec_sw_default = 0x0;
            sw_default_mask = 0x0;
        } ERR8[8:8];
        ERR8->desc="
////1'b1 -> Force Assertion of Latent Error Reporting for ECC DED Error from on-chip SRAM/Fifo from <NV_DLA>.<CBUF>.<WL>
////1'b0 -> Do Nothing
";
        enum ERRSLICE0_LATENTERR_FORCE_ERR7_enum {
            NOFORCE = 1'd0;
            FORCE = 1'd1;
        };
        field {
            encode          = ERRSLICE0_LATENTERR_FORCE_ERR7_enum;
            sw              = w;
            hw              = r;
            spec_access     = w;
            reset           = 0x0;
            reset_mask      = 0x1;
            spec_sw_default = 0x0;
            sw_default_mask = 0x0;
        } ERR7[7:7];
        ERR7->desc="
////1'b1 -> Force Assertion of Latent Error Reporting for ECC SEC Error from on-chip SRAM/Fifo from <NV_DLA>.<CBUF>.<WL>
////1'b0 -> Do Nothing
";
        enum ERRSLICE0_LATENTERR_FORCE_ERR6_enum {
            NOFORCE = 1'd0;
            FORCE = 1'd1;
        };
        field {
            encode          = ERRSLICE0_LATENTERR_FORCE_ERR6_enum;
            sw              = w;
            hw              = r;
            spec_access     = w;
            reset           = 0x0;
            reset_mask      = 0x1;
            spec_sw_default = 0x0;
            sw_default_mask = 0x0;
        } ERR6[6:6];
        ERR6->desc="
////1'b1 -> Force Assertion of Latent Error Reporting for ECC DED Error from on-chip SRAM/Fifo from <NV_DLA>.<CBUF>.<DH>
////1'b0 -> Do Nothing
";
        enum ERRSLICE0_LATENTERR_FORCE_ERR5_enum {
            NOFORCE = 1'd0;
            FORCE = 1'd1;
        };
        field {
            encode          = ERRSLICE0_LATENTERR_FORCE_ERR5_enum;
            sw              = w;
            hw              = r;
            spec_access     = w;
            reset           = 0x0;
            reset_mask      = 0x1;
            spec_sw_default = 0x0;
            sw_default_mask = 0x0;
        } ERR5[5:5];
        ERR5->desc="
////1'b1 -> Force Assertion of Latent Error Reporting for ECC SEC Error from on-chip SRAM/Fifo from <NV_DLA>.<CBUF>.<DH>
////1'b0 -> Do Nothing
";
        enum ERRSLICE0_LATENTERR_FORCE_ERR4_enum {
            NOFORCE = 1'd0;
            FORCE = 1'd1;
        };
        field {
            encode          = ERRSLICE0_LATENTERR_FORCE_ERR4_enum;
            sw              = w;
            hw              = r;
            spec_access     = w;
            reset           = 0x0;
            reset_mask      = 0x1;
            spec_sw_default = 0x0;
            sw_default_mask = 0x0;
        } ERR4[4:4];
        ERR4->desc="
////1'b1 -> Force Assertion of Latent Error Reporting for ECC DED Error from on-chip SRAM/Fifo from <NV_DLA>.<CBUF>.<DL>
////1'b0 -> Do Nothing
";
        enum ERRSLICE0_LATENTERR_FORCE_ERR3_enum {
            NOFORCE = 1'd0;
            FORCE = 1'd1;
        };
        field {
            encode          = ERRSLICE0_LATENTERR_FORCE_ERR3_enum;
            sw              = w;
            hw              = r;
            spec_access     = w;
            reset           = 0x0;
            reset_mask      = 0x1;
            spec_sw_default = 0x0;
            sw_default_mask = 0x0;
        } ERR3[3:3];
        ERR3->desc="
////1'b1 -> Force Assertion of Latent Error Reporting for ECC SEC Error from on-chip SRAM/Fifo from <NV_DLA>.<CBUF>.<DL>
////1'b0 -> Do Nothing
";
        enum ERRSLICE0_LATENTERR_FORCE_ERR2_enum {
            NOFORCE = 1'd0;
            FORCE = 1'd1;
        };
        field {
            encode          = ERRSLICE0_LATENTERR_FORCE_ERR2_enum;
            sw              = w;
            hw              = r;
            spec_access     = w;
            reset           = 0x0;
            reset_mask      = 0x1;
            spec_sw_default = 0x0;
            sw_default_mask = 0x0;
        } ERR2[2:2];
        ERR2->desc="
////1'b1 -> Force Assertion of Latent Error Reporting for ECC DED Error from on-chip SRAM/Fifo from <NV_DLA>.<BDMA>
////1'b0 -> Do Nothing
";
        enum ERRSLICE0_LATENTERR_FORCE_ERR1_enum {
            NOFORCE = 1'd0;
            FORCE = 1'd1;
        };
        field {
            encode          = ERRSLICE0_LATENTERR_FORCE_ERR1_enum;
            sw              = w;
            hw              = r;
            spec_access     = w;
            reset           = 0x0;
            reset_mask      = 0x1;
            spec_sw_default = 0x0;
            sw_default_mask = 0x0;
        } ERR1[1:1];
        ERR1->desc="
////1'b1 -> Force Assertion of Latent Error Reporting for ECC SEC Error from on-chip SRAM/Fifo from <NV_DLA>.<BDMA>
////1'b0 -> Do Nothing
";
        enum ERRSLICE0_LATENTERR_FORCE_ERR0_enum {
            NOFORCE = 1'd0;
            FORCE = 1'd1;
        };
        field {
            encode          = ERRSLICE0_LATENTERR_FORCE_ERR0_enum;
            sw              = w;
            hw              = r;
            spec_access     = w;
            reset           = 0x0;
            reset_mask      = 0x1;
            spec_sw_default = 0x0;
            sw_default_mask = 0x0;
        } ERR0[0:0];
        ERR0->desc="
////1'b1 -> Force Assertion of Latent Error Reporting for Register Parity Error from NV_NVDLA_GLB_FC_err_collator
////1'b0 -> Do Nothing
";
    }ERRSLICE0_LATENTERR_FORCE @0x44;
    reg {
        name = "ERRSLICE0_LATENTERR_STATUS";
        desc = "
////SW must write 1 to clear the fields of this register.
////Bits in this register continue to be logged independent of the value of LatentError_Enable register, to avoid silent dropping of errors.
";
        field {
            sw              = rw;
            hw              = r;
            spec_access     = rw;
            reset           = 0x0;
            reset_mask      = 0x1;
            spec_sw_default = 0x0;
            sw_default_mask = 0x0;
        } ERR31[31:31];
        ERR31->desc="
////1'b1 -> Error_31_pulse[1:0] for ECC SEC Error from on-chip SRAM/Fifo from <NV_DLA>.<CACC>.<D0BUF> was equal to 2'b10.
////1'b0 -> Error_31_pulse[1:0] for ECC SEC Error from on-chip SRAM/Fifo from <NV_DLA>.<CACC>.<D0BUF> was equal to 2'b01.
";
        field {
            sw              = rw;
            hw              = r;
            spec_access     = rw;
            reset           = 0x0;
            reset_mask      = 0x1;
            spec_sw_default = 0x0;
            sw_default_mask = 0x0;
        } ERR30[30:30];
        ERR30->desc="
////1'b1 -> Error_30_pulse[1:0] for ECC DED Error from on-chip SRAM/Fifo from <NV_DLA>.<CACC>.<A7BUF> was equal to 2'b10.
////1'b0 -> Error_30_pulse[1:0] for ECC DED Error from on-chip SRAM/Fifo from <NV_DLA>.<CACC>.<A7BUF> was equal to 2'b01.
";
        field {
            sw              = rw;
            hw              = r;
            spec_access     = rw;
            reset           = 0x0;
            reset_mask      = 0x1;
            spec_sw_default = 0x0;
            sw_default_mask = 0x0;
        } ERR29[29:29];
        ERR29->desc="
////1'b1 -> Error_29_pulse[1:0] for ECC SEC Error from on-chip SRAM/Fifo from <NV_DLA>.<CACC>.<A7BUF> was equal to 2'b10.
////1'b0 -> Error_29_pulse[1:0] for ECC SEC Error from on-chip SRAM/Fifo from <NV_DLA>.<CACC>.<A7BUF> was equal to 2'b01.
";
        field {
            sw              = rw;
            hw              = r;
            spec_access     = rw;
            reset           = 0x0;
            reset_mask      = 0x1;
            spec_sw_default = 0x0;
            sw_default_mask = 0x0;
        } ERR28[28:28];
        ERR28->desc="
////1'b1 -> Error_28_pulse[1:0] for ECC DED Error from on-chip SRAM/Fifo from <NV_DLA>.<CACC>.<A6BUF> was equal to 2'b10.
////1'b0 -> Error_28_pulse[1:0] for ECC DED Error from on-chip SRAM/Fifo from <NV_DLA>.<CACC>.<A6BUF> was equal to 2'b01.
";
        field {
            sw              = rw;
            hw              = r;
            spec_access     = rw;
            reset           = 0x0;
            reset_mask      = 0x1;
            spec_sw_default = 0x0;
            sw_default_mask = 0x0;
        } ERR27[27:27];
        ERR27->desc="
////1'b1 -> Error_27_pulse[1:0] for ECC SEC Error from on-chip SRAM/Fifo from <NV_DLA>.<CACC>.<A6BUF> was equal to 2'b10.
////1'b0 -> Error_27_pulse[1:0] for ECC SEC Error from on-chip SRAM/Fifo from <NV_DLA>.<CACC>.<A6BUF> was equal to 2'b01.
";
        field {
            sw              = rw;
            hw              = r;
            spec_access     = rw;
            reset           = 0x0;
            reset_mask      = 0x1;
            spec_sw_default = 0x0;
            sw_default_mask = 0x0;
        } ERR26[26:26];
        ERR26->desc="
////1'b1 -> Error_26_pulse[1:0] for ECC DED Error from on-chip SRAM/Fifo from <NV_DLA>.<CACC>.<A5BUF> was equal to 2'b10.
////1'b0 -> Error_26_pulse[1:0] for ECC DED Error from on-chip SRAM/Fifo from <NV_DLA>.<CACC>.<A5BUF> was equal to 2'b01.
";
        field {
            sw              = rw;
            hw              = r;
            spec_access     = rw;
            reset           = 0x0;
            reset_mask      = 0x1;
            spec_sw_default = 0x0;
            sw_default_mask = 0x0;
        } ERR25[25:25];
        ERR25->desc="
////1'b1 -> Error_25_pulse[1:0] for ECC SEC Error from on-chip SRAM/Fifo from <NV_DLA>.<CACC>.<A5BUF> was equal to 2'b10.
////1'b0 -> Error_25_pulse[1:0] for ECC SEC Error from on-chip SRAM/Fifo from <NV_DLA>.<CACC>.<A5BUF> was equal to 2'b01.
";
        field {
            sw              = rw;
            hw              = r;
            spec_access     = rw;
            reset           = 0x0;
            reset_mask      = 0x1;
            spec_sw_default = 0x0;
            sw_default_mask = 0x0;
        } ERR24[24:24];
        ERR24->desc="
////1'b1 -> Error_24_pulse[1:0] for ECC DED Error from on-chip SRAM/Fifo from <NV_DLA>.<CACC>.<A4BUF> was equal to 2'b10.
////1'b0 -> Error_24_pulse[1:0] for ECC DED Error from on-chip SRAM/Fifo from <NV_DLA>.<CACC>.<A4BUF> was equal to 2'b01.
";
        field {
            sw              = rw;
            hw              = r;
            spec_access     = rw;
            reset           = 0x0;
            reset_mask      = 0x1;
            spec_sw_default = 0x0;
            sw_default_mask = 0x0;
        } ERR23[23:23];
        ERR23->desc="
////1'b1 -> Error_23_pulse[1:0] for ECC SEC Error from on-chip SRAM/Fifo from <NV_DLA>.<CACC>.<A4BUF> was equal to 2'b10.
////1'b0 -> Error_23_pulse[1:0] for ECC SEC Error from on-chip SRAM/Fifo from <NV_DLA>.<CACC>.<A4BUF> was equal to 2'b01.
";
        field {
            sw              = rw;
            hw              = r;
            spec_access     = rw;
            reset           = 0x0;
            reset_mask      = 0x1;
            spec_sw_default = 0x0;
            sw_default_mask = 0x0;
        } ERR22[22:22];
        ERR22->desc="
////1'b1 -> Error_22_pulse[1:0] for ECC DED Error from on-chip SRAM/Fifo from <NV_DLA>.<CACC>.<A3BUF> was equal to 2'b10.
////1'b0 -> Error_22_pulse[1:0] for ECC DED Error from on-chip SRAM/Fifo from <NV_DLA>.<CACC>.<A3BUF> was equal to 2'b01.
";
        field {
            sw              = rw;
            hw              = r;
            spec_access     = rw;
            reset           = 0x0;
            reset_mask      = 0x1;
            spec_sw_default = 0x0;
            sw_default_mask = 0x0;
        } ERR21[21:21];
        ERR21->desc="
////1'b1 -> Error_21_pulse[1:0] for ECC SEC Error from on-chip SRAM/Fifo from <NV_DLA>.<CACC>.<A3BUF> was equal to 2'b10.
////1'b0 -> Error_21_pulse[1:0] for ECC SEC Error from on-chip SRAM/Fifo from <NV_DLA>.<CACC>.<A3BUF> was equal to 2'b01.
";
        field {
            sw              = rw;
            hw              = r;
            spec_access     = rw;
            reset           = 0x0;
            reset_mask      = 0x1;
            spec_sw_default = 0x0;
            sw_default_mask = 0x0;
        } ERR20[20:20];
        ERR20->desc="
////1'b1 -> Error_20_pulse[1:0] for ECC DED Error from on-chip SRAM/Fifo from <NV_DLA>.<CACC>.<A2BUF> was equal to 2'b10.
////1'b0 -> Error_20_pulse[1:0] for ECC DED Error from on-chip SRAM/Fifo from <NV_DLA>.<CACC>.<A2BUF> was equal to 2'b01.
";
        field {
            sw              = rw;
            hw              = r;
            spec_access     = rw;
            reset           = 0x0;
            reset_mask      = 0x1;
            spec_sw_default = 0x0;
            sw_default_mask = 0x0;
        } ERR19[19:19];
        ERR19->desc="
////1'b1 -> Error_19_pulse[1:0] for ECC SEC Error from on-chip SRAM/Fifo from <NV_DLA>.<CACC>.<A2BUF> was equal to 2'b10.
////1'b0 -> Error_19_pulse[1:0] for ECC SEC Error from on-chip SRAM/Fifo from <NV_DLA>.<CACC>.<A2BUF> was equal to 2'b01.
";
        field {
            sw              = rw;
            hw              = r;
            spec_access     = rw;
            reset           = 0x0;
            reset_mask      = 0x1;
            spec_sw_default = 0x0;
            sw_default_mask = 0x0;
        } ERR18[18:18];
        ERR18->desc="
////1'b1 -> Error_18_pulse[1:0] for ECC DED Error from on-chip SRAM/Fifo from <NV_DLA>.<CACC>.<A1BUF> was equal to 2'b10.
////1'b0 -> Error_18_pulse[1:0] for ECC DED Error from on-chip SRAM/Fifo from <NV_DLA>.<CACC>.<A1BUF> was equal to 2'b01.
";
        field {
            sw              = rw;
            hw              = r;
            spec_access     = rw;
            reset           = 0x0;
            reset_mask      = 0x1;
            spec_sw_default = 0x0;
            sw_default_mask = 0x0;
        } ERR17[17:17];
        ERR17->desc="
////1'b1 -> Error_17_pulse[1:0] for ECC SEC Error from on-chip SRAM/Fifo from <NV_DLA>.<CACC>.<A1BUF> was equal to 2'b10.
////1'b0 -> Error_17_pulse[1:0] for ECC SEC Error from on-chip SRAM/Fifo from <NV_DLA>.<CACC>.<A1BUF> was equal to 2'b01.
";
        field {
            sw              = rw;
            hw              = r;
            spec_access     = rw;
            reset           = 0x0;
            reset_mask      = 0x1;
            spec_sw_default = 0x0;
            sw_default_mask = 0x0;
        } ERR16[16:16];
        ERR16->desc="
////1'b1 -> Error_16_pulse[1:0] for ECC DED Error from on-chip SRAM/Fifo from <NV_DLA>.<CACC>.<A0BUF> was equal to 2'b10.
////1'b0 -> Error_16_pulse[1:0] for ECC DED Error from on-chip SRAM/Fifo from <NV_DLA>.<CACC>.<A0BUF> was equal to 2'b01.
";
        field {
            sw              = rw;
            hw              = r;
            spec_access     = rw;
            reset           = 0x0;
            reset_mask      = 0x1;
            spec_sw_default = 0x0;
            sw_default_mask = 0x0;
        } ERR15[15:15];
        ERR15->desc="
////1'b1 -> Error_15_pulse[1:0] for ECC SEC Error from on-chip SRAM/Fifo from <NV_DLA>.<CACC>.<A0BUF> was equal to 2'b10.
////1'b0 -> Error_15_pulse[1:0] for ECC SEC Error from on-chip SRAM/Fifo from <NV_DLA>.<CACC>.<A0BUF> was equal to 2'b01.
";
        field {
            sw              = rw;
            hw              = r;
            spec_access     = rw;
            reset           = 0x0;
            reset_mask      = 0x1;
            spec_sw_default = 0x0;
            sw_default_mask = 0x0;
        } ERR14[14:14];
        ERR14->desc="
////1'b1 -> Error_14_pulse[1:0] for ECC DED Error from on-chip SRAM/Fifo from <NV_DLA>.<CBUF>.<MH> was equal to 2'b10.
////1'b0 -> Error_14_pulse[1:0] for ECC DED Error from on-chip SRAM/Fifo from <NV_DLA>.<CBUF>.<MH> was equal to 2'b01.
";
        field {
            sw              = rw;
            hw              = r;
            spec_access     = rw;
            reset           = 0x0;
            reset_mask      = 0x1;
            spec_sw_default = 0x0;
            sw_default_mask = 0x0;
        } ERR13[13:13];
        ERR13->desc="
////1'b1 -> Error_13_pulse[1:0] for ECC SEC Error from on-chip SRAM/Fifo from <NV_DLA>.<CBUF>.<MH> was equal to 2'b10.
////1'b0 -> Error_13_pulse[1:0] for ECC SEC Error from on-chip SRAM/Fifo from <NV_DLA>.<CBUF>.<MH> was equal to 2'b01.
";
        field {
            sw              = rw;
            hw              = r;
            spec_access     = rw;
            reset           = 0x0;
            reset_mask      = 0x1;
            spec_sw_default = 0x0;
            sw_default_mask = 0x0;
        } ERR12[12:12];
        ERR12->desc="
////1'b1 -> Error_12_pulse[1:0] for ECC DED Error from on-chip SRAM/Fifo from <NV_DLA>.<CBUF>.<ML> was equal to 2'b10.
////1'b0 -> Error_12_pulse[1:0] for ECC DED Error from on-chip SRAM/Fifo from <NV_DLA>.<CBUF>.<ML> was equal to 2'b01.
";
        field {
            sw              = rw;
            hw              = r;
            spec_access     = rw;
            reset           = 0x0;
            reset_mask      = 0x1;
            spec_sw_default = 0x0;
            sw_default_mask = 0x0;
        } ERR11[11:11];
        ERR11->desc="
////1'b1 -> Error_11_pulse[1:0] for ECC SEC Error from on-chip SRAM/Fifo from <NV_DLA>.<CBUF>.<ML> was equal to 2'b10.
////1'b0 -> Error_11_pulse[1:0] for ECC SEC Error from on-chip SRAM/Fifo from <NV_DLA>.<CBUF>.<ML> was equal to 2'b01.
";
        field {
            sw              = rw;
            hw              = r;
            spec_access     = rw;
            reset           = 0x0;
            reset_mask      = 0x1;
            spec_sw_default = 0x0;
            sw_default_mask = 0x0;
        } ERR10[10:10];
        ERR10->desc="
////1'b1 -> Error_10_pulse[1:0] for ECC DED Error from on-chip SRAM/Fifo from <NV_DLA>.<CBUF>.<WH> was equal to 2'b10.
////1'b0 -> Error_10_pulse[1:0] for ECC DED Error from on-chip SRAM/Fifo from <NV_DLA>.<CBUF>.<WH> was equal to 2'b01.
";
        field {
            sw              = rw;
            hw              = r;
            spec_access     = rw;
            reset           = 0x0;
            reset_mask      = 0x1;
            spec_sw_default = 0x0;
            sw_default_mask = 0x0;
        } ERR9[9:9];
        ERR9->desc="
////1'b1 -> Error_9_pulse[1:0] for ECC SEC Error from on-chip SRAM/Fifo from <NV_DLA>.<CBUF>.<WH> was equal to 2'b10.
////1'b0 -> Error_9_pulse[1:0] for ECC SEC Error from on-chip SRAM/Fifo from <NV_DLA>.<CBUF>.<WH> was equal to 2'b01.
";
        field {
            sw              = rw;
            hw              = r;
            spec_access     = rw;
            reset           = 0x0;
            reset_mask      = 0x1;
            spec_sw_default = 0x0;
            sw_default_mask = 0x0;
        } ERR8[8:8];
        ERR8->desc="
////1'b1 -> Error_8_pulse[1:0] for ECC DED Error from on-chip SRAM/Fifo from <NV_DLA>.<CBUF>.<WL> was equal to 2'b10.
////1'b0 -> Error_8_pulse[1:0] for ECC DED Error from on-chip SRAM/Fifo from <NV_DLA>.<CBUF>.<WL> was equal to 2'b01.
";
        field {
            sw              = rw;
            hw              = r;
            spec_access     = rw;
            reset           = 0x0;
            reset_mask      = 0x1;
            spec_sw_default = 0x0;
            sw_default_mask = 0x0;
        } ERR7[7:7];
        ERR7->desc="
////1'b1 -> Error_7_pulse[1:0] for ECC SEC Error from on-chip SRAM/Fifo from <NV_DLA>.<CBUF>.<WL> was equal to 2'b10.
////1'b0 -> Error_7_pulse[1:0] for ECC SEC Error from on-chip SRAM/Fifo from <NV_DLA>.<CBUF>.<WL> was equal to 2'b01.
";
        field {
            sw              = rw;
            hw              = r;
            spec_access     = rw;
            reset           = 0x0;
            reset_mask      = 0x1;
            spec_sw_default = 0x0;
            sw_default_mask = 0x0;
        } ERR6[6:6];
        ERR6->desc="
////1'b1 -> Error_6_pulse[1:0] for ECC DED Error from on-chip SRAM/Fifo from <NV_DLA>.<CBUF>.<DH> was equal to 2'b10.
////1'b0 -> Error_6_pulse[1:0] for ECC DED Error from on-chip SRAM/Fifo from <NV_DLA>.<CBUF>.<DH> was equal to 2'b01.
";
        field {
            sw              = rw;
            hw              = r;
            spec_access     = rw;
            reset           = 0x0;
            reset_mask      = 0x1;
            spec_sw_default = 0x0;
            sw_default_mask = 0x0;
        } ERR5[5:5];
        ERR5->desc="
////1'b1 -> Error_5_pulse[1:0] for ECC SEC Error from on-chip SRAM/Fifo from <NV_DLA>.<CBUF>.<DH> was equal to 2'b10.
////1'b0 -> Error_5_pulse[1:0] for ECC SEC Error from on-chip SRAM/Fifo from <NV_DLA>.<CBUF>.<DH> was equal to 2'b01.
";
        field {
            sw              = rw;
            hw              = r;
            spec_access     = rw;
            reset           = 0x0;
            reset_mask      = 0x1;
            spec_sw_default = 0x0;
            sw_default_mask = 0x0;
        } ERR4[4:4];
        ERR4->desc="
////1'b1 -> Error_4_pulse[1:0] for ECC DED Error from on-chip SRAM/Fifo from <NV_DLA>.<CBUF>.<DL> was equal to 2'b10.
////1'b0 -> Error_4_pulse[1:0] for ECC DED Error from on-chip SRAM/Fifo from <NV_DLA>.<CBUF>.<DL> was equal to 2'b01.
";
        field {
            sw              = rw;
            hw              = r;
            spec_access     = rw;
            reset           = 0x0;
            reset_mask      = 0x1;
            spec_sw_default = 0x0;
            sw_default_mask = 0x0;
        } ERR3[3:3];
        ERR3->desc="
////1'b1 -> Error_3_pulse[1:0] for ECC SEC Error from on-chip SRAM/Fifo from <NV_DLA>.<CBUF>.<DL> was equal to 2'b10.
////1'b0 -> Error_3_pulse[1:0] for ECC SEC Error from on-chip SRAM/Fifo from <NV_DLA>.<CBUF>.<DL> was equal to 2'b01.
";
        field {
            sw              = rw;
            hw              = r;
            spec_access     = rw;
            reset           = 0x0;
            reset_mask      = 0x1;
            spec_sw_default = 0x0;
            sw_default_mask = 0x0;
        } ERR2[2:2];
        ERR2->desc="
////1'b1 -> Error_2_pulse[1:0] for ECC DED Error from on-chip SRAM/Fifo from <NV_DLA>.<BDMA> was equal to 2'b10.
////1'b0 -> Error_2_pulse[1:0] for ECC DED Error from on-chip SRAM/Fifo from <NV_DLA>.<BDMA> was equal to 2'b01.
";
        field {
            sw              = rw;
            hw              = r;
            spec_access     = rw;
            reset           = 0x0;
            reset_mask      = 0x1;
            spec_sw_default = 0x0;
            sw_default_mask = 0x0;
        } ERR1[1:1];
        ERR1->desc="
////1'b1 -> Error_1_pulse[1:0] for ECC SEC Error from on-chip SRAM/Fifo from <NV_DLA>.<BDMA> was equal to 2'b10.
////1'b0 -> Error_1_pulse[1:0] for ECC SEC Error from on-chip SRAM/Fifo from <NV_DLA>.<BDMA> was equal to 2'b01.
";
        field {
            sw              = rw;
            hw              = r;
            spec_access     = rw;
            reset           = 0x0;
            reset_mask      = 0x1;
            spec_sw_default = 0x0;
            sw_default_mask = 0x0;
        } ERR0[0:0];
        ERR0->desc="
////1'b1 -> Error_0_pulse[1:0] for Register Parity Error from NV_NVDLA_GLB_FC_err_collator was equal to 2'b10.
////1'b0 -> Error_0_pulse[1:0] for Register Parity Error from NV_NVDLA_GLB_FC_err_collator was equal to 2'b01.
";
    }ERRSLICE0_LATENTERR_STATUS @0x48;
    reg {
        name = "ERRSLICE0_COUNTER_RELOAD";
        enum ERRSLICE0_COUNTER_RELOAD_ERR31_enum {
            NORELOAD = 1'd0;
            RELOAD = 1'd1;
        };
        field {
            encode          = ERRSLICE0_COUNTER_RELOAD_ERR31_enum;
            sw              = w;
            hw              = r;
            spec_access     = w;
            reset           = 0x0;
            reset_mask      = 0x1;
            spec_sw_default = 0x0;
            sw_default_mask = 0x0;
        } ERR31[31:31];
        ERR31->desc="
////1'b1 -> Reload Error Counter for ECC SEC Error from on-chip SRAM/Fifo from <NV_DLA>.<CACC>.<D0BUF>
////1'b0 -> Do Nothing
";
        enum ERRSLICE0_COUNTER_RELOAD_ERR30_enum {
            NORELOAD = 1'd0;
            RELOAD = 1'd1;
        };
        field {
            encode          = ERRSLICE0_COUNTER_RELOAD_ERR30_enum;
            sw              = w;
            hw              = r;
            spec_access     = w;
            reset           = 0x0;
            reset_mask      = 0x1;
            spec_sw_default = 0x0;
            sw_default_mask = 0x0;
        } ERR30[30:30];
        ERR30->desc="
////1'b1 -> Reload Error Counter for ECC DED Error from on-chip SRAM/Fifo from <NV_DLA>.<CACC>.<A7BUF>
////1'b0 -> Do Nothing
";
        enum ERRSLICE0_COUNTER_RELOAD_ERR29_enum {
            NORELOAD = 1'd0;
            RELOAD = 1'd1;
        };
        field {
            encode          = ERRSLICE0_COUNTER_RELOAD_ERR29_enum;
            sw              = w;
            hw              = r;
            spec_access     = w;
            reset           = 0x0;
            reset_mask      = 0x1;
            spec_sw_default = 0x0;
            sw_default_mask = 0x0;
        } ERR29[29:29];
        ERR29->desc="
////1'b1 -> Reload Error Counter for ECC SEC Error from on-chip SRAM/Fifo from <NV_DLA>.<CACC>.<A7BUF>
////1'b0 -> Do Nothing
";
        enum ERRSLICE0_COUNTER_RELOAD_ERR28_enum {
            NORELOAD = 1'd0;
            RELOAD = 1'd1;
        };
        field {
            encode          = ERRSLICE0_COUNTER_RELOAD_ERR28_enum;
            sw              = w;
            hw              = r;
            spec_access     = w;
            reset           = 0x0;
            reset_mask      = 0x1;
            spec_sw_default = 0x0;
            sw_default_mask = 0x0;
        } ERR28[28:28];
        ERR28->desc="
////1'b1 -> Reload Error Counter for ECC DED Error from on-chip SRAM/Fifo from <NV_DLA>.<CACC>.<A6BUF>
////1'b0 -> Do Nothing
";
        enum ERRSLICE0_COUNTER_RELOAD_ERR27_enum {
            NORELOAD = 1'd0;
            RELOAD = 1'd1;
        };
        field {
            encode          = ERRSLICE0_COUNTER_RELOAD_ERR27_enum;
            sw              = w;
            hw              = r;
            spec_access     = w;
            reset           = 0x0;
            reset_mask      = 0x1;
            spec_sw_default = 0x0;
            sw_default_mask = 0x0;
        } ERR27[27:27];
        ERR27->desc="
////1'b1 -> Reload Error Counter for ECC SEC Error from on-chip SRAM/Fifo from <NV_DLA>.<CACC>.<A6BUF>
////1'b0 -> Do Nothing
";
        enum ERRSLICE0_COUNTER_RELOAD_ERR26_enum {
            NORELOAD = 1'd0;
            RELOAD = 1'd1;
        };
        field {
            encode          = ERRSLICE0_COUNTER_RELOAD_ERR26_enum;
            sw              = w;
            hw              = r;
            spec_access     = w;
            reset           = 0x0;
            reset_mask      = 0x1;
            spec_sw_default = 0x0;
            sw_default_mask = 0x0;
        } ERR26[26:26];
        ERR26->desc="
////1'b1 -> Reload Error Counter for ECC DED Error from on-chip SRAM/Fifo from <NV_DLA>.<CACC>.<A5BUF>
////1'b0 -> Do Nothing
";
        enum ERRSLICE0_COUNTER_RELOAD_ERR25_enum {
            NORELOAD = 1'd0;
            RELOAD = 1'd1;
        };
        field {
            encode          = ERRSLICE0_COUNTER_RELOAD_ERR25_enum;
            sw              = w;
            hw              = r;
            spec_access     = w;
            reset           = 0x0;
            reset_mask      = 0x1;
            spec_sw_default = 0x0;
            sw_default_mask = 0x0;
        } ERR25[25:25];
        ERR25->desc="
////1'b1 -> Reload Error Counter for ECC SEC Error from on-chip SRAM/Fifo from <NV_DLA>.<CACC>.<A5BUF>
////1'b0 -> Do Nothing
";
        enum ERRSLICE0_COUNTER_RELOAD_ERR24_enum {
            NORELOAD = 1'd0;
            RELOAD = 1'd1;
        };
        field {
            encode          = ERRSLICE0_COUNTER_RELOAD_ERR24_enum;
            sw              = w;
            hw              = r;
            spec_access     = w;
            reset           = 0x0;
            reset_mask      = 0x1;
            spec_sw_default = 0x0;
            sw_default_mask = 0x0;
        } ERR24[24:24];
        ERR24->desc="
////1'b1 -> Reload Error Counter for ECC DED Error from on-chip SRAM/Fifo from <NV_DLA>.<CACC>.<A4BUF>
////1'b0 -> Do Nothing
";
        enum ERRSLICE0_COUNTER_RELOAD_ERR23_enum {
            NORELOAD = 1'd0;
            RELOAD = 1'd1;
        };
        field {
            encode          = ERRSLICE0_COUNTER_RELOAD_ERR23_enum;
            sw              = w;
            hw              = r;
            spec_access     = w;
            reset           = 0x0;
            reset_mask      = 0x1;
            spec_sw_default = 0x0;
            sw_default_mask = 0x0;
        } ERR23[23:23];
        ERR23->desc="
////1'b1 -> Reload Error Counter for ECC SEC Error from on-chip SRAM/Fifo from <NV_DLA>.<CACC>.<A4BUF>
////1'b0 -> Do Nothing
";
        enum ERRSLICE0_COUNTER_RELOAD_ERR22_enum {
            NORELOAD = 1'd0;
            RELOAD = 1'd1;
        };
        field {
            encode          = ERRSLICE0_COUNTER_RELOAD_ERR22_enum;
            sw              = w;
            hw              = r;
            spec_access     = w;
            reset           = 0x0;
            reset_mask      = 0x1;
            spec_sw_default = 0x0;
            sw_default_mask = 0x0;
        } ERR22[22:22];
        ERR22->desc="
////1'b1 -> Reload Error Counter for ECC DED Error from on-chip SRAM/Fifo from <NV_DLA>.<CACC>.<A3BUF>
////1'b0 -> Do Nothing
";
        enum ERRSLICE0_COUNTER_RELOAD_ERR21_enum {
            NORELOAD = 1'd0;
            RELOAD = 1'd1;
        };
        field {
            encode          = ERRSLICE0_COUNTER_RELOAD_ERR21_enum;
            sw              = w;
            hw              = r;
            spec_access     = w;
            reset           = 0x0;
            reset_mask      = 0x1;
            spec_sw_default = 0x0;
            sw_default_mask = 0x0;
        } ERR21[21:21];
        ERR21->desc="
////1'b1 -> Reload Error Counter for ECC SEC Error from on-chip SRAM/Fifo from <NV_DLA>.<CACC>.<A3BUF>
////1'b0 -> Do Nothing
";
        enum ERRSLICE0_COUNTER_RELOAD_ERR20_enum {
            NORELOAD = 1'd0;
            RELOAD = 1'd1;
        };
        field {
            encode          = ERRSLICE0_COUNTER_RELOAD_ERR20_enum;
            sw              = w;
            hw              = r;
            spec_access     = w;
            reset           = 0x0;
            reset_mask      = 0x1;
            spec_sw_default = 0x0;
            sw_default_mask = 0x0;
        } ERR20[20:20];
        ERR20->desc="
////1'b1 -> Reload Error Counter for ECC DED Error from on-chip SRAM/Fifo from <NV_DLA>.<CACC>.<A2BUF>
////1'b0 -> Do Nothing
";
        enum ERRSLICE0_COUNTER_RELOAD_ERR19_enum {
            NORELOAD = 1'd0;
            RELOAD = 1'd1;
        };
        field {
            encode          = ERRSLICE0_COUNTER_RELOAD_ERR19_enum;
            sw              = w;
            hw              = r;
            spec_access     = w;
            reset           = 0x0;
            reset_mask      = 0x1;
            spec_sw_default = 0x0;
            sw_default_mask = 0x0;
        } ERR19[19:19];
        ERR19->desc="
////1'b1 -> Reload Error Counter for ECC SEC Error from on-chip SRAM/Fifo from <NV_DLA>.<CACC>.<A2BUF>
////1'b0 -> Do Nothing
";
        enum ERRSLICE0_COUNTER_RELOAD_ERR18_enum {
            NORELOAD = 1'd0;
            RELOAD = 1'd1;
        };
        field {
            encode          = ERRSLICE0_COUNTER_RELOAD_ERR18_enum;
            sw              = w;
            hw              = r;
            spec_access     = w;
            reset           = 0x0;
            reset_mask      = 0x1;
            spec_sw_default = 0x0;
            sw_default_mask = 0x0;
        } ERR18[18:18];
        ERR18->desc="
////1'b1 -> Reload Error Counter for ECC DED Error from on-chip SRAM/Fifo from <NV_DLA>.<CACC>.<A1BUF>
////1'b0 -> Do Nothing
";
        enum ERRSLICE0_COUNTER_RELOAD_ERR17_enum {
            NORELOAD = 1'd0;
            RELOAD = 1'd1;
        };
        field {
            encode          = ERRSLICE0_COUNTER_RELOAD_ERR17_enum;
            sw              = w;
            hw              = r;
            spec_access     = w;
            reset           = 0x0;
            reset_mask      = 0x1;
            spec_sw_default = 0x0;
            sw_default_mask = 0x0;
        } ERR17[17:17];
        ERR17->desc="
////1'b1 -> Reload Error Counter for ECC SEC Error from on-chip SRAM/Fifo from <NV_DLA>.<CACC>.<A1BUF>
////1'b0 -> Do Nothing
";
        enum ERRSLICE0_COUNTER_RELOAD_ERR16_enum {
            NORELOAD = 1'd0;
            RELOAD = 1'd1;
        };
        field {
            encode          = ERRSLICE0_COUNTER_RELOAD_ERR16_enum;
            sw              = w;
            hw              = r;
            spec_access     = w;
            reset           = 0x0;
            reset_mask      = 0x1;
            spec_sw_default = 0x0;
            sw_default_mask = 0x0;
        } ERR16[16:16];
        ERR16->desc="
////1'b1 -> Reload Error Counter for ECC DED Error from on-chip SRAM/Fifo from <NV_DLA>.<CACC>.<A0BUF>
////1'b0 -> Do Nothing
";
        enum ERRSLICE0_COUNTER_RELOAD_ERR15_enum {
            NORELOAD = 1'd0;
            RELOAD = 1'd1;
        };
        field {
            encode          = ERRSLICE0_COUNTER_RELOAD_ERR15_enum;
            sw              = w;
            hw              = r;
            spec_access     = w;
            reset           = 0x0;
            reset_mask      = 0x1;
            spec_sw_default = 0x0;
            sw_default_mask = 0x0;
        } ERR15[15:15];
        ERR15->desc="
////1'b1 -> Reload Error Counter for ECC SEC Error from on-chip SRAM/Fifo from <NV_DLA>.<CACC>.<A0BUF>
////1'b0 -> Do Nothing
";
        enum ERRSLICE0_COUNTER_RELOAD_ERR14_enum {
            NORELOAD = 1'd0;
            RELOAD = 1'd1;
        };
        field {
            encode          = ERRSLICE0_COUNTER_RELOAD_ERR14_enum;
            sw              = w;
            hw              = r;
            spec_access     = w;
            reset           = 0x0;
            reset_mask      = 0x1;
            spec_sw_default = 0x0;
            sw_default_mask = 0x0;
        } ERR14[14:14];
        ERR14->desc="
////1'b1 -> Reload Error Counter for ECC DED Error from on-chip SRAM/Fifo from <NV_DLA>.<CBUF>.<MH>
////1'b0 -> Do Nothing
";
        enum ERRSLICE0_COUNTER_RELOAD_ERR13_enum {
            NORELOAD = 1'd0;
            RELOAD = 1'd1;
        };
        field {
            encode          = ERRSLICE0_COUNTER_RELOAD_ERR13_enum;
            sw              = w;
            hw              = r;
            spec_access     = w;
            reset           = 0x0;
            reset_mask      = 0x1;
            spec_sw_default = 0x0;
            sw_default_mask = 0x0;
        } ERR13[13:13];
        ERR13->desc="
////1'b1 -> Reload Error Counter for ECC SEC Error from on-chip SRAM/Fifo from <NV_DLA>.<CBUF>.<MH>
////1'b0 -> Do Nothing
";
        enum ERRSLICE0_COUNTER_RELOAD_ERR12_enum {
            NORELOAD = 1'd0;
            RELOAD = 1'd1;
        };
        field {
            encode          = ERRSLICE0_COUNTER_RELOAD_ERR12_enum;
            sw              = w;
            hw              = r;
            spec_access     = w;
            reset           = 0x0;
            reset_mask      = 0x1;
            spec_sw_default = 0x0;
            sw_default_mask = 0x0;
        } ERR12[12:12];
        ERR12->desc="
////1'b1 -> Reload Error Counter for ECC DED Error from on-chip SRAM/Fifo from <NV_DLA>.<CBUF>.<ML>
////1'b0 -> Do Nothing
";
        enum ERRSLICE0_COUNTER_RELOAD_ERR11_enum {
            NORELOAD = 1'd0;
            RELOAD = 1'd1;
        };
        field {
            encode          = ERRSLICE0_COUNTER_RELOAD_ERR11_enum;
            sw              = w;
            hw              = r;
            spec_access     = w;
            reset           = 0x0;
            reset_mask      = 0x1;
            spec_sw_default = 0x0;
            sw_default_mask = 0x0;
        } ERR11[11:11];
        ERR11->desc="
////1'b1 -> Reload Error Counter for ECC SEC Error from on-chip SRAM/Fifo from <NV_DLA>.<CBUF>.<ML>
////1'b0 -> Do Nothing
";
        enum ERRSLICE0_COUNTER_RELOAD_ERR10_enum {
            NORELOAD = 1'd0;
            RELOAD = 1'd1;
        };
        field {
            encode          = ERRSLICE0_COUNTER_RELOAD_ERR10_enum;
            sw              = w;
            hw              = r;
            spec_access     = w;
            reset           = 0x0;
            reset_mask      = 0x1;
            spec_sw_default = 0x0;
            sw_default_mask = 0x0;
        } ERR10[10:10];
        ERR10->desc="
////1'b1 -> Reload Error Counter for ECC DED Error from on-chip SRAM/Fifo from <NV_DLA>.<CBUF>.<WH>
////1'b0 -> Do Nothing
";
        enum ERRSLICE0_COUNTER_RELOAD_ERR9_enum {
            NORELOAD = 1'd0;
            RELOAD = 1'd1;
        };
        field {
            encode          = ERRSLICE0_COUNTER_RELOAD_ERR9_enum;
            sw              = w;
            hw              = r;
            spec_access     = w;
            reset           = 0x0;
            reset_mask      = 0x1;
            spec_sw_default = 0x0;
            sw_default_mask = 0x0;
        } ERR9[9:9];
        ERR9->desc="
////1'b1 -> Reload Error Counter for ECC SEC Error from on-chip SRAM/Fifo from <NV_DLA>.<CBUF>.<WH>
////1'b0 -> Do Nothing
";
        enum ERRSLICE0_COUNTER_RELOAD_ERR8_enum {
            NORELOAD = 1'd0;
            RELOAD = 1'd1;
        };
        field {
            encode          = ERRSLICE0_COUNTER_RELOAD_ERR8_enum;
            sw              = w;
            hw              = r;
            spec_access     = w;
            reset           = 0x0;
            reset_mask      = 0x1;
            spec_sw_default = 0x0;
            sw_default_mask = 0x0;
        } ERR8[8:8];
        ERR8->desc="
////1'b1 -> Reload Error Counter for ECC DED Error from on-chip SRAM/Fifo from <NV_DLA>.<CBUF>.<WL>
////1'b0 -> Do Nothing
";
        enum ERRSLICE0_COUNTER_RELOAD_ERR7_enum {
            NORELOAD = 1'd0;
            RELOAD = 1'd1;
        };
        field {
            encode          = ERRSLICE0_COUNTER_RELOAD_ERR7_enum;
            sw              = w;
            hw              = r;
            spec_access     = w;
            reset           = 0x0;
            reset_mask      = 0x1;
            spec_sw_default = 0x0;
            sw_default_mask = 0x0;
        } ERR7[7:7];
        ERR7->desc="
////1'b1 -> Reload Error Counter for ECC SEC Error from on-chip SRAM/Fifo from <NV_DLA>.<CBUF>.<WL>
////1'b0 -> Do Nothing
";
        enum ERRSLICE0_COUNTER_RELOAD_ERR6_enum {
            NORELOAD = 1'd0;
            RELOAD = 1'd1;
        };
        field {
            encode          = ERRSLICE0_COUNTER_RELOAD_ERR6_enum;
            sw              = w;
            hw              = r;
            spec_access     = w;
            reset           = 0x0;
            reset_mask      = 0x1;
            spec_sw_default = 0x0;
            sw_default_mask = 0x0;
        } ERR6[6:6];
        ERR6->desc="
////1'b1 -> Reload Error Counter for ECC DED Error from on-chip SRAM/Fifo from <NV_DLA>.<CBUF>.<DH>
////1'b0 -> Do Nothing
";
        enum ERRSLICE0_COUNTER_RELOAD_ERR5_enum {
            NORELOAD = 1'd0;
            RELOAD = 1'd1;
        };
        field {
            encode          = ERRSLICE0_COUNTER_RELOAD_ERR5_enum;
            sw              = w;
            hw              = r;
            spec_access     = w;
            reset           = 0x0;
            reset_mask      = 0x1;
            spec_sw_default = 0x0;
            sw_default_mask = 0x0;
        } ERR5[5:5];
        ERR5->desc="
////1'b1 -> Reload Error Counter for ECC SEC Error from on-chip SRAM/Fifo from <NV_DLA>.<CBUF>.<DH>
////1'b0 -> Do Nothing
";
        enum ERRSLICE0_COUNTER_RELOAD_ERR4_enum {
            NORELOAD = 1'd0;
            RELOAD = 1'd1;
        };
        field {
            encode          = ERRSLICE0_COUNTER_RELOAD_ERR4_enum;
            sw              = w;
            hw              = r;
            spec_access     = w;
            reset           = 0x0;
            reset_mask      = 0x1;
            spec_sw_default = 0x0;
            sw_default_mask = 0x0;
        } ERR4[4:4];
        ERR4->desc="
////1'b1 -> Reload Error Counter for ECC DED Error from on-chip SRAM/Fifo from <NV_DLA>.<CBUF>.<DL>
////1'b0 -> Do Nothing
";
        enum ERRSLICE0_COUNTER_RELOAD_ERR3_enum {
            NORELOAD = 1'd0;
            RELOAD = 1'd1;
        };
        field {
            encode          = ERRSLICE0_COUNTER_RELOAD_ERR3_enum;
            sw              = w;
            hw              = r;
            spec_access     = w;
            reset           = 0x0;
            reset_mask      = 0x1;
            spec_sw_default = 0x0;
            sw_default_mask = 0x0;
        } ERR3[3:3];
        ERR3->desc="
////1'b1 -> Reload Error Counter for ECC SEC Error from on-chip SRAM/Fifo from <NV_DLA>.<CBUF>.<DL>
////1'b0 -> Do Nothing
";
        enum ERRSLICE0_COUNTER_RELOAD_ERR2_enum {
            NORELOAD = 1'd0;
            RELOAD = 1'd1;
        };
        field {
            encode          = ERRSLICE0_COUNTER_RELOAD_ERR2_enum;
            sw              = w;
            hw              = r;
            spec_access     = w;
            reset           = 0x0;
            reset_mask      = 0x1;
            spec_sw_default = 0x0;
            sw_default_mask = 0x0;
        } ERR2[2:2];
        ERR2->desc="
////1'b1 -> Reload Error Counter for ECC DED Error from on-chip SRAM/Fifo from <NV_DLA>.<BDMA>
////1'b0 -> Do Nothing
";
        enum ERRSLICE0_COUNTER_RELOAD_ERR1_enum {
            NORELOAD = 1'd0;
            RELOAD = 1'd1;
        };
        field {
            encode          = ERRSLICE0_COUNTER_RELOAD_ERR1_enum;
            sw              = w;
            hw              = r;
            spec_access     = w;
            reset           = 0x0;
            reset_mask      = 0x1;
            spec_sw_default = 0x0;
            sw_default_mask = 0x0;
        } ERR1[1:1];
        ERR1->desc="
////1'b1 -> Reload Error Counter for ECC SEC Error from on-chip SRAM/Fifo from <NV_DLA>.<BDMA>
////1'b0 -> Do Nothing
";
        enum ERRSLICE0_COUNTER_RELOAD_ERR0_enum {
            NORELOAD = 1'd0;
            RELOAD = 1'd1;
        };
        field {
            encode          = ERRSLICE0_COUNTER_RELOAD_ERR0_enum;
            sw              = w;
            hw              = r;
            spec_access     = w;
            reset           = 0x0;
            reset_mask      = 0x1;
            spec_sw_default = 0x0;
            sw_default_mask = 0x0;
        } ERR0[0:0];
        ERR0->desc="
////1'b1 -> Reload Error Counter for Register Parity Error from NV_NVDLA_GLB_FC_err_collator
////1'b0 -> Do Nothing
";
    }ERRSLICE0_COUNTER_RELOAD @0x50;
    reg {
        name = "ERRSLICE1_MISSIONERR_ENABLE";
        desc = "
//// 0x28 to 0x30 = Reserved for future use.
////==================================
//// ERROR SLICE - 1
////==================================
";
        enum ERRSLICE1_MISSIONERR_ENABLE_ERR63_enum {
            DISABLE = 1'd0;
            ENABLE = 1'd1;
        };
        field {
            encode          = ERRSLICE1_MISSIONERR_ENABLE_ERR63_enum;
            sw              = rw;
            hw              = r;
            spec_access     = rw;
            reset           = 0x1;
            reset_mask      = 0x1;
            spec_sw_default = 0x0;
            sw_default_mask = 0x0;
        } ERR63[31:31];
        ERR63->desc="
////1'b1 -> Enable  Mission Error Reporting for ECC SEC Error from on-chip SRAM/Fifo from <NV_DLA>.<FALCON>.<IMEM>
////1'b0 -> Disable Mission Error Reporting for ECC SEC Error from on-chip SRAM/Fifo from <NV_DLA>.<FALCON>.<IMEM>
";
        enum ERRSLICE1_MISSIONERR_ENABLE_ERR62_enum {
            DISABLE = 1'd0;
            ENABLE = 1'd1;
        };
        field {
            encode          = ERRSLICE1_MISSIONERR_ENABLE_ERR62_enum;
            sw              = rw;
            hw              = r;
            spec_access     = rw;
            reset           = 0x1;
            reset_mask      = 0x1;
            spec_sw_default = 0x0;
            sw_default_mask = 0x0;
        } ERR62[30:30];
        ERR62->desc="
////1'b1 -> Enable  Mission Error Reporting for ECC DED Error from on-chip SRAM/Fifo from <NV_DLA>.<RUBIK>.<FIFO_B>
////1'b0 -> Disable Mission Error Reporting for ECC DED Error from on-chip SRAM/Fifo from <NV_DLA>.<RUBIK>.<FIFO_B>
";
        enum ERRSLICE1_MISSIONERR_ENABLE_ERR61_enum {
            DISABLE = 1'd0;
            ENABLE = 1'd1;
        };
        field {
            encode          = ERRSLICE1_MISSIONERR_ENABLE_ERR61_enum;
            sw              = rw;
            hw              = r;
            spec_access     = rw;
            reset           = 0x1;
            reset_mask      = 0x1;
            spec_sw_default = 0x0;
            sw_default_mask = 0x0;
        } ERR61[29:29];
        ERR61->desc="
////1'b1 -> Enable  Mission Error Reporting for ECC SEC Error from on-chip SRAM/Fifo from <NV_DLA>.<RUBIK>.<FIFO_B>
////1'b0 -> Disable Mission Error Reporting for ECC SEC Error from on-chip SRAM/Fifo from <NV_DLA>.<RUBIK>.<FIFO_B>
";
        enum ERRSLICE1_MISSIONERR_ENABLE_ERR60_enum {
            DISABLE = 1'd0;
            ENABLE = 1'd1;
        };
        field {
            encode          = ERRSLICE1_MISSIONERR_ENABLE_ERR60_enum;
            sw              = rw;
            hw              = r;
            spec_access     = rw;
            reset           = 0x1;
            reset_mask      = 0x1;
            spec_sw_default = 0x0;
            sw_default_mask = 0x0;
        } ERR60[28:28];
        ERR60->desc="
////1'b1 -> Enable  Mission Error Reporting for ECC DED Error from on-chip SRAM/Fifo from <NV_DLA>.<RUBIK>.<FIFO_A>
////1'b0 -> Disable Mission Error Reporting for ECC DED Error from on-chip SRAM/Fifo from <NV_DLA>.<RUBIK>.<FIFO_A>
";
        enum ERRSLICE1_MISSIONERR_ENABLE_ERR59_enum {
            DISABLE = 1'd0;
            ENABLE = 1'd1;
        };
        field {
            encode          = ERRSLICE1_MISSIONERR_ENABLE_ERR59_enum;
            sw              = rw;
            hw              = r;
            spec_access     = rw;
            reset           = 0x1;
            reset_mask      = 0x1;
            spec_sw_default = 0x0;
            sw_default_mask = 0x0;
        } ERR59[27:27];
        ERR59->desc="
////1'b1 -> Enable  Mission Error Reporting for ECC SEC Error from on-chip SRAM/Fifo from <NV_DLA>.<RUBIK>.<FIFO_A>
////1'b0 -> Disable Mission Error Reporting for ECC SEC Error from on-chip SRAM/Fifo from <NV_DLA>.<RUBIK>.<FIFO_A>
";
        enum ERRSLICE1_MISSIONERR_ENABLE_ERR58_enum {
            DISABLE = 1'd0;
            ENABLE = 1'd1;
        };
        field {
            encode          = ERRSLICE1_MISSIONERR_ENABLE_ERR58_enum;
            sw              = rw;
            hw              = r;
            spec_access     = rw;
            reset           = 0x1;
            reset_mask      = 0x1;
            spec_sw_default = 0x0;
            sw_default_mask = 0x0;
        } ERR58[26:26];
        ERR58->desc="
////1'b1 -> Enable  Mission Error Reporting for ECC DED Error from on-chip SRAM/Fifo from <NV_DLA>.<CDP>
////1'b0 -> Disable Mission Error Reporting for ECC DED Error from on-chip SRAM/Fifo from <NV_DLA>.<CDP>
";
        enum ERRSLICE1_MISSIONERR_ENABLE_ERR57_enum {
            DISABLE = 1'd0;
            ENABLE = 1'd1;
        };
        field {
            encode          = ERRSLICE1_MISSIONERR_ENABLE_ERR57_enum;
            sw              = rw;
            hw              = r;
            spec_access     = rw;
            reset           = 0x1;
            reset_mask      = 0x1;
            spec_sw_default = 0x0;
            sw_default_mask = 0x0;
        } ERR57[25:25];
        ERR57->desc="
////1'b1 -> Enable  Mission Error Reporting for ECC SEC Error from on-chip SRAM/Fifo from <NV_DLA>.<CDP>
////1'b0 -> Disable Mission Error Reporting for ECC SEC Error from on-chip SRAM/Fifo from <NV_DLA>.<CDP>
";
        enum ERRSLICE1_MISSIONERR_ENABLE_ERR56_enum {
            DISABLE = 1'd0;
            ENABLE = 1'd1;
        };
        field {
            encode          = ERRSLICE1_MISSIONERR_ENABLE_ERR56_enum;
            sw              = rw;
            hw              = r;
            spec_access     = rw;
            reset           = 0x1;
            reset_mask      = 0x1;
            spec_sw_default = 0x0;
            sw_default_mask = 0x0;
        } ERR56[24:24];
        ERR56->desc="
////1'b1 -> Enable  Mission Error Reporting for ECC DED Error from on-chip SRAM/Fifo from <NV_DLA>.<PDP>
////1'b0 -> Disable Mission Error Reporting for ECC DED Error from on-chip SRAM/Fifo from <NV_DLA>.<PDP>
";
        enum ERRSLICE1_MISSIONERR_ENABLE_ERR55_enum {
            DISABLE = 1'd0;
            ENABLE = 1'd1;
        };
        field {
            encode          = ERRSLICE1_MISSIONERR_ENABLE_ERR55_enum;
            sw              = rw;
            hw              = r;
            spec_access     = rw;
            reset           = 0x1;
            reset_mask      = 0x1;
            spec_sw_default = 0x0;
            sw_default_mask = 0x0;
        } ERR55[23:23];
        ERR55->desc="
////1'b1 -> Enable  Mission Error Reporting for ECC SEC Error from on-chip SRAM/Fifo from <NV_DLA>.<PDP>
////1'b0 -> Disable Mission Error Reporting for ECC SEC Error from on-chip SRAM/Fifo from <NV_DLA>.<PDP>
";
        enum ERRSLICE1_MISSIONERR_ENABLE_ERR54_enum {
            DISABLE = 1'd0;
            ENABLE = 1'd1;
        };
        field {
            encode          = ERRSLICE1_MISSIONERR_ENABLE_ERR54_enum;
            sw              = rw;
            hw              = r;
            spec_access     = rw;
            reset           = 0x1;
            reset_mask      = 0x1;
            spec_sw_default = 0x0;
            sw_default_mask = 0x0;
        } ERR54[22:22];
        ERR54->desc="
////1'b1 -> Enable  Mission Error Reporting for ECC DED Error from on-chip SRAM/Fifo from <NV_DLA>.<SDP>.<E2>
////1'b0 -> Disable Mission Error Reporting for ECC DED Error from on-chip SRAM/Fifo from <NV_DLA>.<SDP>.<E2>
";
        enum ERRSLICE1_MISSIONERR_ENABLE_ERR53_enum {
            DISABLE = 1'd0;
            ENABLE = 1'd1;
        };
        field {
            encode          = ERRSLICE1_MISSIONERR_ENABLE_ERR53_enum;
            sw              = rw;
            hw              = r;
            spec_access     = rw;
            reset           = 0x1;
            reset_mask      = 0x1;
            spec_sw_default = 0x0;
            sw_default_mask = 0x0;
        } ERR53[21:21];
        ERR53->desc="
////1'b1 -> Enable  Mission Error Reporting for ECC SEC Error from on-chip SRAM/Fifo from <NV_DLA>.<SDP>.<E2>
////1'b0 -> Disable Mission Error Reporting for ECC SEC Error from on-chip SRAM/Fifo from <NV_DLA>.<SDP>.<E2>
";
        enum ERRSLICE1_MISSIONERR_ENABLE_ERR52_enum {
            DISABLE = 1'd0;
            ENABLE = 1'd1;
        };
        field {
            encode          = ERRSLICE1_MISSIONERR_ENABLE_ERR52_enum;
            sw              = rw;
            hw              = r;
            spec_access     = rw;
            reset           = 0x1;
            reset_mask      = 0x1;
            spec_sw_default = 0x0;
            sw_default_mask = 0x0;
        } ERR52[20:20];
        ERR52->desc="
////1'b1 -> Enable  Mission Error Reporting for ECC DED Error from on-chip SRAM/Fifo from <NV_DLA>.<SDP>.<N2>
////1'b0 -> Disable Mission Error Reporting for ECC DED Error from on-chip SRAM/Fifo from <NV_DLA>.<SDP>.<N2>
";
        enum ERRSLICE1_MISSIONERR_ENABLE_ERR51_enum {
            DISABLE = 1'd0;
            ENABLE = 1'd1;
        };
        field {
            encode          = ERRSLICE1_MISSIONERR_ENABLE_ERR51_enum;
            sw              = rw;
            hw              = r;
            spec_access     = rw;
            reset           = 0x1;
            reset_mask      = 0x1;
            spec_sw_default = 0x0;
            sw_default_mask = 0x0;
        } ERR51[19:19];
        ERR51->desc="
////1'b1 -> Enable  Mission Error Reporting for ECC SEC Error from on-chip SRAM/Fifo from <NV_DLA>.<SDP>.<N2>
////1'b0 -> Disable Mission Error Reporting for ECC SEC Error from on-chip SRAM/Fifo from <NV_DLA>.<SDP>.<N2>
";
        enum ERRSLICE1_MISSIONERR_ENABLE_ERR50_enum {
            DISABLE = 1'd0;
            ENABLE = 1'd1;
        };
        field {
            encode          = ERRSLICE1_MISSIONERR_ENABLE_ERR50_enum;
            sw              = rw;
            hw              = r;
            spec_access     = rw;
            reset           = 0x1;
            reset_mask      = 0x1;
            spec_sw_default = 0x0;
            sw_default_mask = 0x0;
        } ERR50[18:18];
        ERR50->desc="
////1'b1 -> Enable  Mission Error Reporting for ECC DED Error from on-chip SRAM/Fifo from <NV_DLA>.<SDP>.<B2>
////1'b0 -> Disable Mission Error Reporting for ECC DED Error from on-chip SRAM/Fifo from <NV_DLA>.<SDP>.<B2>
";
        enum ERRSLICE1_MISSIONERR_ENABLE_ERR49_enum {
            DISABLE = 1'd0;
            ENABLE = 1'd1;
        };
        field {
            encode          = ERRSLICE1_MISSIONERR_ENABLE_ERR49_enum;
            sw              = rw;
            hw              = r;
            spec_access     = rw;
            reset           = 0x1;
            reset_mask      = 0x1;
            spec_sw_default = 0x0;
            sw_default_mask = 0x0;
        } ERR49[17:17];
        ERR49->desc="
////1'b1 -> Enable  Mission Error Reporting for ECC SEC Error from on-chip SRAM/Fifo from <NV_DLA>.<SDP>.<B2>
////1'b0 -> Disable Mission Error Reporting for ECC SEC Error from on-chip SRAM/Fifo from <NV_DLA>.<SDP>.<B2>
";
        enum ERRSLICE1_MISSIONERR_ENABLE_ERR48_enum {
            DISABLE = 1'd0;
            ENABLE = 1'd1;
        };
        field {
            encode          = ERRSLICE1_MISSIONERR_ENABLE_ERR48_enum;
            sw              = rw;
            hw              = r;
            spec_access     = rw;
            reset           = 0x1;
            reset_mask      = 0x1;
            spec_sw_default = 0x0;
            sw_default_mask = 0x0;
        } ERR48[16:16];
        ERR48->desc="
////1'b1 -> Enable  Mission Error Reporting for ECC DED Error from on-chip SRAM/Fifo from <NV_DLA>.<SDP>
////1'b0 -> Disable Mission Error Reporting for ECC DED Error from on-chip SRAM/Fifo from <NV_DLA>.<SDP>
";
        enum ERRSLICE1_MISSIONERR_ENABLE_ERR47_enum {
            DISABLE = 1'd0;
            ENABLE = 1'd1;
        };
        field {
            encode          = ERRSLICE1_MISSIONERR_ENABLE_ERR47_enum;
            sw              = rw;
            hw              = r;
            spec_access     = rw;
            reset           = 0x1;
            reset_mask      = 0x1;
            spec_sw_default = 0x0;
            sw_default_mask = 0x0;
        } ERR47[15:15];
        ERR47->desc="
////1'b1 -> Enable  Mission Error Reporting for ECC SEC Error from on-chip SRAM/Fifo from <NV_DLA>.<SDP>
////1'b0 -> Disable Mission Error Reporting for ECC SEC Error from on-chip SRAM/Fifo from <NV_DLA>.<SDP>
";
        enum ERRSLICE1_MISSIONERR_ENABLE_ERR46_enum {
            DISABLE = 1'd0;
            ENABLE = 1'd1;
        };
        field {
            encode          = ERRSLICE1_MISSIONERR_ENABLE_ERR46_enum;
            sw              = rw;
            hw              = r;
            spec_access     = rw;
            reset           = 0x1;
            reset_mask      = 0x1;
            spec_sw_default = 0x0;
            sw_default_mask = 0x0;
        } ERR46[14:14];
        ERR46->desc="
////1'b1 -> Enable  Mission Error Reporting for ECC DED Error from on-chip SRAM/Fifo from <NV_DLA>.<CACC>.<D7BUF>
////1'b0 -> Disable Mission Error Reporting for ECC DED Error from on-chip SRAM/Fifo from <NV_DLA>.<CACC>.<D7BUF>
";
        enum ERRSLICE1_MISSIONERR_ENABLE_ERR45_enum {
            DISABLE = 1'd0;
            ENABLE = 1'd1;
        };
        field {
            encode          = ERRSLICE1_MISSIONERR_ENABLE_ERR45_enum;
            sw              = rw;
            hw              = r;
            spec_access     = rw;
            reset           = 0x1;
            reset_mask      = 0x1;
            spec_sw_default = 0x0;
            sw_default_mask = 0x0;
        } ERR45[13:13];
        ERR45->desc="
////1'b1 -> Enable  Mission Error Reporting for ECC SEC Error from on-chip SRAM/Fifo from <NV_DLA>.<CACC>.<D7BUF>
////1'b0 -> Disable Mission Error Reporting for ECC SEC Error from on-chip SRAM/Fifo from <NV_DLA>.<CACC>.<D7BUF>
";
        enum ERRSLICE1_MISSIONERR_ENABLE_ERR44_enum {
            DISABLE = 1'd0;
            ENABLE = 1'd1;
        };
        field {
            encode          = ERRSLICE1_MISSIONERR_ENABLE_ERR44_enum;
            sw              = rw;
            hw              = r;
            spec_access     = rw;
            reset           = 0x1;
            reset_mask      = 0x1;
            spec_sw_default = 0x0;
            sw_default_mask = 0x0;
        } ERR44[12:12];
        ERR44->desc="
////1'b1 -> Enable  Mission Error Reporting for ECC DED Error from on-chip SRAM/Fifo from <NV_DLA>.<CACC>.<D6BUF>
////1'b0 -> Disable Mission Error Reporting for ECC DED Error from on-chip SRAM/Fifo from <NV_DLA>.<CACC>.<D6BUF>
";
        enum ERRSLICE1_MISSIONERR_ENABLE_ERR43_enum {
            DISABLE = 1'd0;
            ENABLE = 1'd1;
        };
        field {
            encode          = ERRSLICE1_MISSIONERR_ENABLE_ERR43_enum;
            sw              = rw;
            hw              = r;
            spec_access     = rw;
            reset           = 0x1;
            reset_mask      = 0x1;
            spec_sw_default = 0x0;
            sw_default_mask = 0x0;
        } ERR43[11:11];
        ERR43->desc="
////1'b1 -> Enable  Mission Error Reporting for ECC SEC Error from on-chip SRAM/Fifo from <NV_DLA>.<CACC>.<D6BUF>
////1'b0 -> Disable Mission Error Reporting for ECC SEC Error from on-chip SRAM/Fifo from <NV_DLA>.<CACC>.<D6BUF>
";
        enum ERRSLICE1_MISSIONERR_ENABLE_ERR42_enum {
            DISABLE = 1'd0;
            ENABLE = 1'd1;
        };
        field {
            encode          = ERRSLICE1_MISSIONERR_ENABLE_ERR42_enum;
            sw              = rw;
            hw              = r;
            spec_access     = rw;
            reset           = 0x1;
            reset_mask      = 0x1;
            spec_sw_default = 0x0;
            sw_default_mask = 0x0;
        } ERR42[10:10];
        ERR42->desc="
////1'b1 -> Enable  Mission Error Reporting for ECC DED Error from on-chip SRAM/Fifo from <NV_DLA>.<CACC>.<D5BUF>
////1'b0 -> Disable Mission Error Reporting for ECC DED Error from on-chip SRAM/Fifo from <NV_DLA>.<CACC>.<D5BUF>
";
        enum ERRSLICE1_MISSIONERR_ENABLE_ERR41_enum {
            DISABLE = 1'd0;
            ENABLE = 1'd1;
        };
        field {
            encode          = ERRSLICE1_MISSIONERR_ENABLE_ERR41_enum;
            sw              = rw;
            hw              = r;
            spec_access     = rw;
            reset           = 0x1;
            reset_mask      = 0x1;
            spec_sw_default = 0x0;
            sw_default_mask = 0x0;
        } ERR41[9:9];
        ERR41->desc="
////1'b1 -> Enable  Mission Error Reporting for ECC SEC Error from on-chip SRAM/Fifo from <NV_DLA>.<CACC>.<D5BUF>
////1'b0 -> Disable Mission Error Reporting for ECC SEC Error from on-chip SRAM/Fifo from <NV_DLA>.<CACC>.<D5BUF>
";
        enum ERRSLICE1_MISSIONERR_ENABLE_ERR40_enum {
            DISABLE = 1'd0;
            ENABLE = 1'd1;
        };
        field {
            encode          = ERRSLICE1_MISSIONERR_ENABLE_ERR40_enum;
            sw              = rw;
            hw              = r;
            spec_access     = rw;
            reset           = 0x1;
            reset_mask      = 0x1;
            spec_sw_default = 0x0;
            sw_default_mask = 0x0;
        } ERR40[8:8];
        ERR40->desc="
////1'b1 -> Enable  Mission Error Reporting for ECC DED Error from on-chip SRAM/Fifo from <NV_DLA>.<CACC>.<D4BUF>
////1'b0 -> Disable Mission Error Reporting for ECC DED Error from on-chip SRAM/Fifo from <NV_DLA>.<CACC>.<D4BUF>
";
        enum ERRSLICE1_MISSIONERR_ENABLE_ERR39_enum {
            DISABLE = 1'd0;
            ENABLE = 1'd1;
        };
        field {
            encode          = ERRSLICE1_MISSIONERR_ENABLE_ERR39_enum;
            sw              = rw;
            hw              = r;
            spec_access     = rw;
            reset           = 0x1;
            reset_mask      = 0x1;
            spec_sw_default = 0x0;
            sw_default_mask = 0x0;
        } ERR39[7:7];
        ERR39->desc="
////1'b1 -> Enable  Mission Error Reporting for ECC SEC Error from on-chip SRAM/Fifo from <NV_DLA>.<CACC>.<D4BUF>
////1'b0 -> Disable Mission Error Reporting for ECC SEC Error from on-chip SRAM/Fifo from <NV_DLA>.<CACC>.<D4BUF>
";
        enum ERRSLICE1_MISSIONERR_ENABLE_ERR38_enum {
            DISABLE = 1'd0;
            ENABLE = 1'd1;
        };
        field {
            encode          = ERRSLICE1_MISSIONERR_ENABLE_ERR38_enum;
            sw              = rw;
            hw              = r;
            spec_access     = rw;
            reset           = 0x1;
            reset_mask      = 0x1;
            spec_sw_default = 0x0;
            sw_default_mask = 0x0;
        } ERR38[6:6];
        ERR38->desc="
////1'b1 -> Enable  Mission Error Reporting for ECC DED Error from on-chip SRAM/Fifo from <NV_DLA>.<CACC>.<D3BUF>
////1'b0 -> Disable Mission Error Reporting for ECC DED Error from on-chip SRAM/Fifo from <NV_DLA>.<CACC>.<D3BUF>
";
        enum ERRSLICE1_MISSIONERR_ENABLE_ERR37_enum {
            DISABLE = 1'd0;
            ENABLE = 1'd1;
        };
        field {
            encode          = ERRSLICE1_MISSIONERR_ENABLE_ERR37_enum;
            sw              = rw;
            hw              = r;
            spec_access     = rw;
            reset           = 0x1;
            reset_mask      = 0x1;
            spec_sw_default = 0x0;
            sw_default_mask = 0x0;
        } ERR37[5:5];
        ERR37->desc="
////1'b1 -> Enable  Mission Error Reporting for ECC SEC Error from on-chip SRAM/Fifo from <NV_DLA>.<CACC>.<D3BUF>
////1'b0 -> Disable Mission Error Reporting for ECC SEC Error from on-chip SRAM/Fifo from <NV_DLA>.<CACC>.<D3BUF>
";
        enum ERRSLICE1_MISSIONERR_ENABLE_ERR36_enum {
            DISABLE = 1'd0;
            ENABLE = 1'd1;
        };
        field {
            encode          = ERRSLICE1_MISSIONERR_ENABLE_ERR36_enum;
            sw              = rw;
            hw              = r;
            spec_access     = rw;
            reset           = 0x1;
            reset_mask      = 0x1;
            spec_sw_default = 0x0;
            sw_default_mask = 0x0;
        } ERR36[4:4];
        ERR36->desc="
////1'b1 -> Enable  Mission Error Reporting for ECC DED Error from on-chip SRAM/Fifo from <NV_DLA>.<CACC>.<D2BUF>
////1'b0 -> Disable Mission Error Reporting for ECC DED Error from on-chip SRAM/Fifo from <NV_DLA>.<CACC>.<D2BUF>
";
        enum ERRSLICE1_MISSIONERR_ENABLE_ERR35_enum {
            DISABLE = 1'd0;
            ENABLE = 1'd1;
        };
        field {
            encode          = ERRSLICE1_MISSIONERR_ENABLE_ERR35_enum;
            sw              = rw;
            hw              = r;
            spec_access     = rw;
            reset           = 0x1;
            reset_mask      = 0x1;
            spec_sw_default = 0x0;
            sw_default_mask = 0x0;
        } ERR35[3:3];
        ERR35->desc="
////1'b1 -> Enable  Mission Error Reporting for ECC SEC Error from on-chip SRAM/Fifo from <NV_DLA>.<CACC>.<D2BUF>
////1'b0 -> Disable Mission Error Reporting for ECC SEC Error from on-chip SRAM/Fifo from <NV_DLA>.<CACC>.<D2BUF>
";
        enum ERRSLICE1_MISSIONERR_ENABLE_ERR34_enum {
            DISABLE = 1'd0;
            ENABLE = 1'd1;
        };
        field {
            encode          = ERRSLICE1_MISSIONERR_ENABLE_ERR34_enum;
            sw              = rw;
            hw              = r;
            spec_access     = rw;
            reset           = 0x1;
            reset_mask      = 0x1;
            spec_sw_default = 0x0;
            sw_default_mask = 0x0;
        } ERR34[2:2];
        ERR34->desc="
////1'b1 -> Enable  Mission Error Reporting for ECC DED Error from on-chip SRAM/Fifo from <NV_DLA>.<CACC>.<D1BUF>
////1'b0 -> Disable Mission Error Reporting for ECC DED Error from on-chip SRAM/Fifo from <NV_DLA>.<CACC>.<D1BUF>
";
        enum ERRSLICE1_MISSIONERR_ENABLE_ERR33_enum {
            DISABLE = 1'd0;
            ENABLE = 1'd1;
        };
        field {
            encode          = ERRSLICE1_MISSIONERR_ENABLE_ERR33_enum;
            sw              = rw;
            hw              = r;
            spec_access     = rw;
            reset           = 0x1;
            reset_mask      = 0x1;
            spec_sw_default = 0x0;
            sw_default_mask = 0x0;
        } ERR33[1:1];
        ERR33->desc="
////1'b1 -> Enable  Mission Error Reporting for ECC SEC Error from on-chip SRAM/Fifo from <NV_DLA>.<CACC>.<D1BUF>
////1'b0 -> Disable Mission Error Reporting for ECC SEC Error from on-chip SRAM/Fifo from <NV_DLA>.<CACC>.<D1BUF>
";
        enum ERRSLICE1_MISSIONERR_ENABLE_ERR32_enum {
            DISABLE = 1'd0;
            ENABLE = 1'd1;
        };
        field {
            encode          = ERRSLICE1_MISSIONERR_ENABLE_ERR32_enum;
            sw              = rw;
            hw              = r;
            spec_access     = rw;
            reset           = 0x1;
            reset_mask      = 0x1;
            spec_sw_default = 0x0;
            sw_default_mask = 0x0;
        } ERR32[0:0];
        ERR32->desc="
////1'b1 -> Enable  Mission Error Reporting for ECC DED Error from on-chip SRAM/Fifo from <NV_DLA>.<CACC>.<D0BUF>
////1'b0 -> Disable Mission Error Reporting for ECC DED Error from on-chip SRAM/Fifo from <NV_DLA>.<CACC>.<D0BUF>
";
    }ERRSLICE1_MISSIONERR_ENABLE @0x60;
    reg {
        name = "ERRSLICE1_MISSIONERR_FORCE";
        enum ERRSLICE1_MISSIONERR_FORCE_ERR63_enum {
            NOFORCE = 1'd0;
            FORCE = 1'd1;
        };
        field {
            encode          = ERRSLICE1_MISSIONERR_FORCE_ERR63_enum;
            sw              = w;
            hw              = r;
            spec_access     = w;
            reset           = 0x0;
            reset_mask      = 0x1;
            spec_sw_default = 0x0;
            sw_default_mask = 0x0;
        } ERR63[31:31];
        ERR63->desc="
////1'b1 -> Force Assertion of Mission Error Reporting for ECC SEC Error from on-chip SRAM/Fifo from <NV_DLA>.<FALCON>.<IMEM>
////1'b0 -> Do Nothing
";
        enum ERRSLICE1_MISSIONERR_FORCE_ERR62_enum {
            NOFORCE = 1'd0;
            FORCE = 1'd1;
        };
        field {
            encode          = ERRSLICE1_MISSIONERR_FORCE_ERR62_enum;
            sw              = w;
            hw              = r;
            spec_access     = w;
            reset           = 0x0;
            reset_mask      = 0x1;
            spec_sw_default = 0x0;
            sw_default_mask = 0x0;
        } ERR62[30:30];
        ERR62->desc="
////1'b1 -> Force Assertion of Mission Error Reporting for ECC DED Error from on-chip SRAM/Fifo from <NV_DLA>.<RUBIK>.<FIFO_B>
////1'b0 -> Do Nothing
";
        enum ERRSLICE1_MISSIONERR_FORCE_ERR61_enum {
            NOFORCE = 1'd0;
            FORCE = 1'd1;
        };
        field {
            encode          = ERRSLICE1_MISSIONERR_FORCE_ERR61_enum;
            sw              = w;
            hw              = r;
            spec_access     = w;
            reset           = 0x0;
            reset_mask      = 0x1;
            spec_sw_default = 0x0;
            sw_default_mask = 0x0;
        } ERR61[29:29];
        ERR61->desc="
////1'b1 -> Force Assertion of Mission Error Reporting for ECC SEC Error from on-chip SRAM/Fifo from <NV_DLA>.<RUBIK>.<FIFO_B>
////1'b0 -> Do Nothing
";
        enum ERRSLICE1_MISSIONERR_FORCE_ERR60_enum {
            NOFORCE = 1'd0;
            FORCE = 1'd1;
        };
        field {
            encode          = ERRSLICE1_MISSIONERR_FORCE_ERR60_enum;
            sw              = w;
            hw              = r;
            spec_access     = w;
            reset           = 0x0;
            reset_mask      = 0x1;
            spec_sw_default = 0x0;
            sw_default_mask = 0x0;
        } ERR60[28:28];
        ERR60->desc="
////1'b1 -> Force Assertion of Mission Error Reporting for ECC DED Error from on-chip SRAM/Fifo from <NV_DLA>.<RUBIK>.<FIFO_A>
////1'b0 -> Do Nothing
";
        enum ERRSLICE1_MISSIONERR_FORCE_ERR59_enum {
            NOFORCE = 1'd0;
            FORCE = 1'd1;
        };
        field {
            encode          = ERRSLICE1_MISSIONERR_FORCE_ERR59_enum;
            sw              = w;
            hw              = r;
            spec_access     = w;
            reset           = 0x0;
            reset_mask      = 0x1;
            spec_sw_default = 0x0;
            sw_default_mask = 0x0;
        } ERR59[27:27];
        ERR59->desc="
////1'b1 -> Force Assertion of Mission Error Reporting for ECC SEC Error from on-chip SRAM/Fifo from <NV_DLA>.<RUBIK>.<FIFO_A>
////1'b0 -> Do Nothing
";
        enum ERRSLICE1_MISSIONERR_FORCE_ERR58_enum {
            NOFORCE = 1'd0;
            FORCE = 1'd1;
        };
        field {
            encode          = ERRSLICE1_MISSIONERR_FORCE_ERR58_enum;
            sw              = w;
            hw              = r;
            spec_access     = w;
            reset           = 0x0;
            reset_mask      = 0x1;
            spec_sw_default = 0x0;
            sw_default_mask = 0x0;
        } ERR58[26:26];
        ERR58->desc="
////1'b1 -> Force Assertion of Mission Error Reporting for ECC DED Error from on-chip SRAM/Fifo from <NV_DLA>.<CDP>
////1'b0 -> Do Nothing
";
        enum ERRSLICE1_MISSIONERR_FORCE_ERR57_enum {
            NOFORCE = 1'd0;
            FORCE = 1'd1;
        };
        field {
            encode          = ERRSLICE1_MISSIONERR_FORCE_ERR57_enum;
            sw              = w;
            hw              = r;
            spec_access     = w;
            reset           = 0x0;
            reset_mask      = 0x1;
            spec_sw_default = 0x0;
            sw_default_mask = 0x0;
        } ERR57[25:25];
        ERR57->desc="
////1'b1 -> Force Assertion of Mission Error Reporting for ECC SEC Error from on-chip SRAM/Fifo from <NV_DLA>.<CDP>
////1'b0 -> Do Nothing
";
        enum ERRSLICE1_MISSIONERR_FORCE_ERR56_enum {
            NOFORCE = 1'd0;
            FORCE = 1'd1;
        };
        field {
            encode          = ERRSLICE1_MISSIONERR_FORCE_ERR56_enum;
            sw              = w;
            hw              = r;
            spec_access     = w;
            reset           = 0x0;
            reset_mask      = 0x1;
            spec_sw_default = 0x0;
            sw_default_mask = 0x0;
        } ERR56[24:24];
        ERR56->desc="
////1'b1 -> Force Assertion of Mission Error Reporting for ECC DED Error from on-chip SRAM/Fifo from <NV_DLA>.<PDP>
////1'b0 -> Do Nothing
";
        enum ERRSLICE1_MISSIONERR_FORCE_ERR55_enum {
            NOFORCE = 1'd0;
            FORCE = 1'd1;
        };
        field {
            encode          = ERRSLICE1_MISSIONERR_FORCE_ERR55_enum;
            sw              = w;
            hw              = r;
            spec_access     = w;
            reset           = 0x0;
            reset_mask      = 0x1;
            spec_sw_default = 0x0;
            sw_default_mask = 0x0;
        } ERR55[23:23];
        ERR55->desc="
////1'b1 -> Force Assertion of Mission Error Reporting for ECC SEC Error from on-chip SRAM/Fifo from <NV_DLA>.<PDP>
////1'b0 -> Do Nothing
";
        enum ERRSLICE1_MISSIONERR_FORCE_ERR54_enum {
            NOFORCE = 1'd0;
            FORCE = 1'd1;
        };
        field {
            encode          = ERRSLICE1_MISSIONERR_FORCE_ERR54_enum;
            sw              = w;
            hw              = r;
            spec_access     = w;
            reset           = 0x0;
            reset_mask      = 0x1;
            spec_sw_default = 0x0;
            sw_default_mask = 0x0;
        } ERR54[22:22];
        ERR54->desc="
////1'b1 -> Force Assertion of Mission Error Reporting for ECC DED Error from on-chip SRAM/Fifo from <NV_DLA>.<SDP>.<E2>
////1'b0 -> Do Nothing
";
        enum ERRSLICE1_MISSIONERR_FORCE_ERR53_enum {
            NOFORCE = 1'd0;
            FORCE = 1'd1;
        };
        field {
            encode          = ERRSLICE1_MISSIONERR_FORCE_ERR53_enum;
            sw              = w;
            hw              = r;
            spec_access     = w;
            reset           = 0x0;
            reset_mask      = 0x1;
            spec_sw_default = 0x0;
            sw_default_mask = 0x0;
        } ERR53[21:21];
        ERR53->desc="
////1'b1 -> Force Assertion of Mission Error Reporting for ECC SEC Error from on-chip SRAM/Fifo from <NV_DLA>.<SDP>.<E2>
////1'b0 -> Do Nothing
";
        enum ERRSLICE1_MISSIONERR_FORCE_ERR52_enum {
            NOFORCE = 1'd0;
            FORCE = 1'd1;
        };
        field {
            encode          = ERRSLICE1_MISSIONERR_FORCE_ERR52_enum;
            sw              = w;
            hw              = r;
            spec_access     = w;
            reset           = 0x0;
            reset_mask      = 0x1;
            spec_sw_default = 0x0;
            sw_default_mask = 0x0;
        } ERR52[20:20];
        ERR52->desc="
////1'b1 -> Force Assertion of Mission Error Reporting for ECC DED Error from on-chip SRAM/Fifo from <NV_DLA>.<SDP>.<N2>
////1'b0 -> Do Nothing
";
        enum ERRSLICE1_MISSIONERR_FORCE_ERR51_enum {
            NOFORCE = 1'd0;
            FORCE = 1'd1;
        };
        field {
            encode          = ERRSLICE1_MISSIONERR_FORCE_ERR51_enum;
            sw              = w;
            hw              = r;
            spec_access     = w;
            reset           = 0x0;
            reset_mask      = 0x1;
            spec_sw_default = 0x0;
            sw_default_mask = 0x0;
        } ERR51[19:19];
        ERR51->desc="
////1'b1 -> Force Assertion of Mission Error Reporting for ECC SEC Error from on-chip SRAM/Fifo from <NV_DLA>.<SDP>.<N2>
////1'b0 -> Do Nothing
";
        enum ERRSLICE1_MISSIONERR_FORCE_ERR50_enum {
            NOFORCE = 1'd0;
            FORCE = 1'd1;
        };
        field {
            encode          = ERRSLICE1_MISSIONERR_FORCE_ERR50_enum;
            sw              = w;
            hw              = r;
            spec_access     = w;
            reset           = 0x0;
            reset_mask      = 0x1;
            spec_sw_default = 0x0;
            sw_default_mask = 0x0;
        } ERR50[18:18];
        ERR50->desc="
////1'b1 -> Force Assertion of Mission Error Reporting for ECC DED Error from on-chip SRAM/Fifo from <NV_DLA>.<SDP>.<B2>
////1'b0 -> Do Nothing
";
        enum ERRSLICE1_MISSIONERR_FORCE_ERR49_enum {
            NOFORCE = 1'd0;
            FORCE = 1'd1;
        };
        field {
            encode          = ERRSLICE1_MISSIONERR_FORCE_ERR49_enum;
            sw              = w;
            hw              = r;
            spec_access     = w;
            reset           = 0x0;
            reset_mask      = 0x1;
            spec_sw_default = 0x0;
            sw_default_mask = 0x0;
        } ERR49[17:17];
        ERR49->desc="
////1'b1 -> Force Assertion of Mission Error Reporting for ECC SEC Error from on-chip SRAM/Fifo from <NV_DLA>.<SDP>.<B2>
////1'b0 -> Do Nothing
";
        enum ERRSLICE1_MISSIONERR_FORCE_ERR48_enum {
            NOFORCE = 1'd0;
            FORCE = 1'd1;
        };
        field {
            encode          = ERRSLICE1_MISSIONERR_FORCE_ERR48_enum;
            sw              = w;
            hw              = r;
            spec_access     = w;
            reset           = 0x0;
            reset_mask      = 0x1;
            spec_sw_default = 0x0;
            sw_default_mask = 0x0;
        } ERR48[16:16];
        ERR48->desc="
////1'b1 -> Force Assertion of Mission Error Reporting for ECC DED Error from on-chip SRAM/Fifo from <NV_DLA>.<SDP>
////1'b0 -> Do Nothing
";
        enum ERRSLICE1_MISSIONERR_FORCE_ERR47_enum {
            NOFORCE = 1'd0;
            FORCE = 1'd1;
        };
        field {
            encode          = ERRSLICE1_MISSIONERR_FORCE_ERR47_enum;
            sw              = w;
            hw              = r;
            spec_access     = w;
            reset           = 0x0;
            reset_mask      = 0x1;
            spec_sw_default = 0x0;
            sw_default_mask = 0x0;
        } ERR47[15:15];
        ERR47->desc="
////1'b1 -> Force Assertion of Mission Error Reporting for ECC SEC Error from on-chip SRAM/Fifo from <NV_DLA>.<SDP>
////1'b0 -> Do Nothing
";
        enum ERRSLICE1_MISSIONERR_FORCE_ERR46_enum {
            NOFORCE = 1'd0;
            FORCE = 1'd1;
        };
        field {
            encode          = ERRSLICE1_MISSIONERR_FORCE_ERR46_enum;
            sw              = w;
            hw              = r;
            spec_access     = w;
            reset           = 0x0;
            reset_mask      = 0x1;
            spec_sw_default = 0x0;
            sw_default_mask = 0x0;
        } ERR46[14:14];
        ERR46->desc="
////1'b1 -> Force Assertion of Mission Error Reporting for ECC DED Error from on-chip SRAM/Fifo from <NV_DLA>.<CACC>.<D7BUF>
////1'b0 -> Do Nothing
";
        enum ERRSLICE1_MISSIONERR_FORCE_ERR45_enum {
            NOFORCE = 1'd0;
            FORCE = 1'd1;
        };
        field {
            encode          = ERRSLICE1_MISSIONERR_FORCE_ERR45_enum;
            sw              = w;
            hw              = r;
            spec_access     = w;
            reset           = 0x0;
            reset_mask      = 0x1;
            spec_sw_default = 0x0;
            sw_default_mask = 0x0;
        } ERR45[13:13];
        ERR45->desc="
////1'b1 -> Force Assertion of Mission Error Reporting for ECC SEC Error from on-chip SRAM/Fifo from <NV_DLA>.<CACC>.<D7BUF>
////1'b0 -> Do Nothing
";
        enum ERRSLICE1_MISSIONERR_FORCE_ERR44_enum {
            NOFORCE = 1'd0;
            FORCE = 1'd1;
        };
        field {
            encode          = ERRSLICE1_MISSIONERR_FORCE_ERR44_enum;
            sw              = w;
            hw              = r;
            spec_access     = w;
            reset           = 0x0;
            reset_mask      = 0x1;
            spec_sw_default = 0x0;
            sw_default_mask = 0x0;
        } ERR44[12:12];
        ERR44->desc="
////1'b1 -> Force Assertion of Mission Error Reporting for ECC DED Error from on-chip SRAM/Fifo from <NV_DLA>.<CACC>.<D6BUF>
////1'b0 -> Do Nothing
";
        enum ERRSLICE1_MISSIONERR_FORCE_ERR43_enum {
            NOFORCE = 1'd0;
            FORCE = 1'd1;
        };
        field {
            encode          = ERRSLICE1_MISSIONERR_FORCE_ERR43_enum;
            sw              = w;
            hw              = r;
            spec_access     = w;
            reset           = 0x0;
            reset_mask      = 0x1;
            spec_sw_default = 0x0;
            sw_default_mask = 0x0;
        } ERR43[11:11];
        ERR43->desc="
////1'b1 -> Force Assertion of Mission Error Reporting for ECC SEC Error from on-chip SRAM/Fifo from <NV_DLA>.<CACC>.<D6BUF>
////1'b0 -> Do Nothing
";
        enum ERRSLICE1_MISSIONERR_FORCE_ERR42_enum {
            NOFORCE = 1'd0;
            FORCE = 1'd1;
        };
        field {
            encode          = ERRSLICE1_MISSIONERR_FORCE_ERR42_enum;
            sw              = w;
            hw              = r;
            spec_access     = w;
            reset           = 0x0;
            reset_mask      = 0x1;
            spec_sw_default = 0x0;
            sw_default_mask = 0x0;
        } ERR42[10:10];
        ERR42->desc="
////1'b1 -> Force Assertion of Mission Error Reporting for ECC DED Error from on-chip SRAM/Fifo from <NV_DLA>.<CACC>.<D5BUF>
////1'b0 -> Do Nothing
";
        enum ERRSLICE1_MISSIONERR_FORCE_ERR41_enum {
            NOFORCE = 1'd0;
            FORCE = 1'd1;
        };
        field {
            encode          = ERRSLICE1_MISSIONERR_FORCE_ERR41_enum;
            sw              = w;
            hw              = r;
            spec_access     = w;
            reset           = 0x0;
            reset_mask      = 0x1;
            spec_sw_default = 0x0;
            sw_default_mask = 0x0;
        } ERR41[9:9];
        ERR41->desc="
////1'b1 -> Force Assertion of Mission Error Reporting for ECC SEC Error from on-chip SRAM/Fifo from <NV_DLA>.<CACC>.<D5BUF>
////1'b0 -> Do Nothing
";
        enum ERRSLICE1_MISSIONERR_FORCE_ERR40_enum {
            NOFORCE = 1'd0;
            FORCE = 1'd1;
        };
        field {
            encode          = ERRSLICE1_MISSIONERR_FORCE_ERR40_enum;
            sw              = w;
            hw              = r;
            spec_access     = w;
            reset           = 0x0;
            reset_mask      = 0x1;
            spec_sw_default = 0x0;
            sw_default_mask = 0x0;
        } ERR40[8:8];
        ERR40->desc="
////1'b1 -> Force Assertion of Mission Error Reporting for ECC DED Error from on-chip SRAM/Fifo from <NV_DLA>.<CACC>.<D4BUF>
////1'b0 -> Do Nothing
";
        enum ERRSLICE1_MISSIONERR_FORCE_ERR39_enum {
            NOFORCE = 1'd0;
            FORCE = 1'd1;
        };
        field {
            encode          = ERRSLICE1_MISSIONERR_FORCE_ERR39_enum;
            sw              = w;
            hw              = r;
            spec_access     = w;
            reset           = 0x0;
            reset_mask      = 0x1;
            spec_sw_default = 0x0;
            sw_default_mask = 0x0;
        } ERR39[7:7];
        ERR39->desc="
////1'b1 -> Force Assertion of Mission Error Reporting for ECC SEC Error from on-chip SRAM/Fifo from <NV_DLA>.<CACC>.<D4BUF>
////1'b0 -> Do Nothing
";
        enum ERRSLICE1_MISSIONERR_FORCE_ERR38_enum {
            NOFORCE = 1'd0;
            FORCE = 1'd1;
        };
        field {
            encode          = ERRSLICE1_MISSIONERR_FORCE_ERR38_enum;
            sw              = w;
            hw              = r;
            spec_access     = w;
            reset           = 0x0;
            reset_mask      = 0x1;
            spec_sw_default = 0x0;
            sw_default_mask = 0x0;
        } ERR38[6:6];
        ERR38->desc="
////1'b1 -> Force Assertion of Mission Error Reporting for ECC DED Error from on-chip SRAM/Fifo from <NV_DLA>.<CACC>.<D3BUF>
////1'b0 -> Do Nothing
";
        enum ERRSLICE1_MISSIONERR_FORCE_ERR37_enum {
            NOFORCE = 1'd0;
            FORCE = 1'd1;
        };
        field {
            encode          = ERRSLICE1_MISSIONERR_FORCE_ERR37_enum;
            sw              = w;
            hw              = r;
            spec_access     = w;
            reset           = 0x0;
            reset_mask      = 0x1;
            spec_sw_default = 0x0;
            sw_default_mask = 0x0;
        } ERR37[5:5];
        ERR37->desc="
////1'b1 -> Force Assertion of Mission Error Reporting for ECC SEC Error from on-chip SRAM/Fifo from <NV_DLA>.<CACC>.<D3BUF>
////1'b0 -> Do Nothing
";
        enum ERRSLICE1_MISSIONERR_FORCE_ERR36_enum {
            NOFORCE = 1'd0;
            FORCE = 1'd1;
        };
        field {
            encode          = ERRSLICE1_MISSIONERR_FORCE_ERR36_enum;
            sw              = w;
            hw              = r;
            spec_access     = w;
            reset           = 0x0;
            reset_mask      = 0x1;
            spec_sw_default = 0x0;
            sw_default_mask = 0x0;
        } ERR36[4:4];
        ERR36->desc="
////1'b1 -> Force Assertion of Mission Error Reporting for ECC DED Error from on-chip SRAM/Fifo from <NV_DLA>.<CACC>.<D2BUF>
////1'b0 -> Do Nothing
";
        enum ERRSLICE1_MISSIONERR_FORCE_ERR35_enum {
            NOFORCE = 1'd0;
            FORCE = 1'd1;
        };
        field {
            encode          = ERRSLICE1_MISSIONERR_FORCE_ERR35_enum;
            sw              = w;
            hw              = r;
            spec_access     = w;
            reset           = 0x0;
            reset_mask      = 0x1;
            spec_sw_default = 0x0;
            sw_default_mask = 0x0;
        } ERR35[3:3];
        ERR35->desc="
////1'b1 -> Force Assertion of Mission Error Reporting for ECC SEC Error from on-chip SRAM/Fifo from <NV_DLA>.<CACC>.<D2BUF>
////1'b0 -> Do Nothing
";
        enum ERRSLICE1_MISSIONERR_FORCE_ERR34_enum {
            NOFORCE = 1'd0;
            FORCE = 1'd1;
        };
        field {
            encode          = ERRSLICE1_MISSIONERR_FORCE_ERR34_enum;
            sw              = w;
            hw              = r;
            spec_access     = w;
            reset           = 0x0;
            reset_mask      = 0x1;
            spec_sw_default = 0x0;
            sw_default_mask = 0x0;
        } ERR34[2:2];
        ERR34->desc="
////1'b1 -> Force Assertion of Mission Error Reporting for ECC DED Error from on-chip SRAM/Fifo from <NV_DLA>.<CACC>.<D1BUF>
////1'b0 -> Do Nothing
";
        enum ERRSLICE1_MISSIONERR_FORCE_ERR33_enum {
            NOFORCE = 1'd0;
            FORCE = 1'd1;
        };
        field {
            encode          = ERRSLICE1_MISSIONERR_FORCE_ERR33_enum;
            sw              = w;
            hw              = r;
            spec_access     = w;
            reset           = 0x0;
            reset_mask      = 0x1;
            spec_sw_default = 0x0;
            sw_default_mask = 0x0;
        } ERR33[1:1];
        ERR33->desc="
////1'b1 -> Force Assertion of Mission Error Reporting for ECC SEC Error from on-chip SRAM/Fifo from <NV_DLA>.<CACC>.<D1BUF>
////1'b0 -> Do Nothing
";
        enum ERRSLICE1_MISSIONERR_FORCE_ERR32_enum {
            NOFORCE = 1'd0;
            FORCE = 1'd1;
        };
        field {
            encode          = ERRSLICE1_MISSIONERR_FORCE_ERR32_enum;
            sw              = w;
            hw              = r;
            spec_access     = w;
            reset           = 0x0;
            reset_mask      = 0x1;
            spec_sw_default = 0x0;
            sw_default_mask = 0x0;
        } ERR32[0:0];
        ERR32->desc="
////1'b1 -> Force Assertion of Mission Error Reporting for ECC DED Error from on-chip SRAM/Fifo from <NV_DLA>.<CACC>.<D0BUF>
////1'b0 -> Do Nothing
";
    }ERRSLICE1_MISSIONERR_FORCE @0x64;
    reg {
        name = "ERRSLICE1_MISSIONERR_STATUS";
        desc = "
////SW must write 1 to clear the fields of this register.
////Bits in this register continue to be logged independent of the value of MissionError_Enable register, to avoid silent dropping of errors.
";
        field {
            sw              = rw;
            hw              = r;
            spec_access     = rw;
            reset           = 0x0;
            reset_mask      = 0x1;
            spec_sw_default = 0x0;
            sw_default_mask = 0x0;
        } ERR63[31:31];
        ERR63->desc="
////1'b1 -> Error_63_pulse[1:0] for ECC SEC Error from on-chip SRAM/Fifo from <NV_DLA>.<FALCON>.<IMEM> was equal to 2'b10.
////1'b0 -> Error_63_pulse[1:0] for ECC SEC Error from on-chip SRAM/Fifo from <NV_DLA>.<FALCON>.<IMEM> was equal to 2'b01.
";
        field {
            sw              = rw;
            hw              = r;
            spec_access     = rw;
            reset           = 0x0;
            reset_mask      = 0x1;
            spec_sw_default = 0x0;
            sw_default_mask = 0x0;
        } ERR62[30:30];
        ERR62->desc="
////1'b1 -> Error_62_pulse[1:0] for ECC DED Error from on-chip SRAM/Fifo from <NV_DLA>.<RUBIK>.<FIFO_B> was equal to 2'b10.
////1'b0 -> Error_62_pulse[1:0] for ECC DED Error from on-chip SRAM/Fifo from <NV_DLA>.<RUBIK>.<FIFO_B> was equal to 2'b01.
";
        field {
            sw              = rw;
            hw              = r;
            spec_access     = rw;
            reset           = 0x0;
            reset_mask      = 0x1;
            spec_sw_default = 0x0;
            sw_default_mask = 0x0;
        } ERR61[29:29];
        ERR61->desc="
////1'b1 -> Error_61_pulse[1:0] for ECC SEC Error from on-chip SRAM/Fifo from <NV_DLA>.<RUBIK>.<FIFO_B> was equal to 2'b10.
////1'b0 -> Error_61_pulse[1:0] for ECC SEC Error from on-chip SRAM/Fifo from <NV_DLA>.<RUBIK>.<FIFO_B> was equal to 2'b01.
";
        field {
            sw              = rw;
            hw              = r;
            spec_access     = rw;
            reset           = 0x0;
            reset_mask      = 0x1;
            spec_sw_default = 0x0;
            sw_default_mask = 0x0;
        } ERR60[28:28];
        ERR60->desc="
////1'b1 -> Error_60_pulse[1:0] for ECC DED Error from on-chip SRAM/Fifo from <NV_DLA>.<RUBIK>.<FIFO_A> was equal to 2'b10.
////1'b0 -> Error_60_pulse[1:0] for ECC DED Error from on-chip SRAM/Fifo from <NV_DLA>.<RUBIK>.<FIFO_A> was equal to 2'b01.
";
        field {
            sw              = rw;
            hw              = r;
            spec_access     = rw;
            reset           = 0x0;
            reset_mask      = 0x1;
            spec_sw_default = 0x0;
            sw_default_mask = 0x0;
        } ERR59[27:27];
        ERR59->desc="
////1'b1 -> Error_59_pulse[1:0] for ECC SEC Error from on-chip SRAM/Fifo from <NV_DLA>.<RUBIK>.<FIFO_A> was equal to 2'b10.
////1'b0 -> Error_59_pulse[1:0] for ECC SEC Error from on-chip SRAM/Fifo from <NV_DLA>.<RUBIK>.<FIFO_A> was equal to 2'b01.
";
        field {
            sw              = rw;
            hw              = r;
            spec_access     = rw;
            reset           = 0x0;
            reset_mask      = 0x1;
            spec_sw_default = 0x0;
            sw_default_mask = 0x0;
        } ERR58[26:26];
        ERR58->desc="
////1'b1 -> Error_58_pulse[1:0] for ECC DED Error from on-chip SRAM/Fifo from <NV_DLA>.<CDP> was equal to 2'b10.
////1'b0 -> Error_58_pulse[1:0] for ECC DED Error from on-chip SRAM/Fifo from <NV_DLA>.<CDP> was equal to 2'b01.
";
        field {
            sw              = rw;
            hw              = r;
            spec_access     = rw;
            reset           = 0x0;
            reset_mask      = 0x1;
            spec_sw_default = 0x0;
            sw_default_mask = 0x0;
        } ERR57[25:25];
        ERR57->desc="
////1'b1 -> Error_57_pulse[1:0] for ECC SEC Error from on-chip SRAM/Fifo from <NV_DLA>.<CDP> was equal to 2'b10.
////1'b0 -> Error_57_pulse[1:0] for ECC SEC Error from on-chip SRAM/Fifo from <NV_DLA>.<CDP> was equal to 2'b01.
";
        field {
            sw              = rw;
            hw              = r;
            spec_access     = rw;
            reset           = 0x0;
            reset_mask      = 0x1;
            spec_sw_default = 0x0;
            sw_default_mask = 0x0;
        } ERR56[24:24];
        ERR56->desc="
////1'b1 -> Error_56_pulse[1:0] for ECC DED Error from on-chip SRAM/Fifo from <NV_DLA>.<PDP> was equal to 2'b10.
////1'b0 -> Error_56_pulse[1:0] for ECC DED Error from on-chip SRAM/Fifo from <NV_DLA>.<PDP> was equal to 2'b01.
";
        field {
            sw              = rw;
            hw              = r;
            spec_access     = rw;
            reset           = 0x0;
            reset_mask      = 0x1;
            spec_sw_default = 0x0;
            sw_default_mask = 0x0;
        } ERR55[23:23];
        ERR55->desc="
////1'b1 -> Error_55_pulse[1:0] for ECC SEC Error from on-chip SRAM/Fifo from <NV_DLA>.<PDP> was equal to 2'b10.
////1'b0 -> Error_55_pulse[1:0] for ECC SEC Error from on-chip SRAM/Fifo from <NV_DLA>.<PDP> was equal to 2'b01.
";
        field {
            sw              = rw;
            hw              = r;
            spec_access     = rw;
            reset           = 0x0;
            reset_mask      = 0x1;
            spec_sw_default = 0x0;
            sw_default_mask = 0x0;
        } ERR54[22:22];
        ERR54->desc="
////1'b1 -> Error_54_pulse[1:0] for ECC DED Error from on-chip SRAM/Fifo from <NV_DLA>.<SDP>.<E2> was equal to 2'b10.
////1'b0 -> Error_54_pulse[1:0] for ECC DED Error from on-chip SRAM/Fifo from <NV_DLA>.<SDP>.<E2> was equal to 2'b01.
";
        field {
            sw              = rw;
            hw              = r;
            spec_access     = rw;
            reset           = 0x0;
            reset_mask      = 0x1;
            spec_sw_default = 0x0;
            sw_default_mask = 0x0;
        } ERR53[21:21];
        ERR53->desc="
////1'b1 -> Error_53_pulse[1:0] for ECC SEC Error from on-chip SRAM/Fifo from <NV_DLA>.<SDP>.<E2> was equal to 2'b10.
////1'b0 -> Error_53_pulse[1:0] for ECC SEC Error from on-chip SRAM/Fifo from <NV_DLA>.<SDP>.<E2> was equal to 2'b01.
";
        field {
            sw              = rw;
            hw              = r;
            spec_access     = rw;
            reset           = 0x0;
            reset_mask      = 0x1;
            spec_sw_default = 0x0;
            sw_default_mask = 0x0;
        } ERR52[20:20];
        ERR52->desc="
////1'b1 -> Error_52_pulse[1:0] for ECC DED Error from on-chip SRAM/Fifo from <NV_DLA>.<SDP>.<N2> was equal to 2'b10.
////1'b0 -> Error_52_pulse[1:0] for ECC DED Error from on-chip SRAM/Fifo from <NV_DLA>.<SDP>.<N2> was equal to 2'b01.
";
        field {
            sw              = rw;
            hw              = r;
            spec_access     = rw;
            reset           = 0x0;
            reset_mask      = 0x1;
            spec_sw_default = 0x0;
            sw_default_mask = 0x0;
        } ERR51[19:19];
        ERR51->desc="
////1'b1 -> Error_51_pulse[1:0] for ECC SEC Error from on-chip SRAM/Fifo from <NV_DLA>.<SDP>.<N2> was equal to 2'b10.
////1'b0 -> Error_51_pulse[1:0] for ECC SEC Error from on-chip SRAM/Fifo from <NV_DLA>.<SDP>.<N2> was equal to 2'b01.
";
        field {
            sw              = rw;
            hw              = r;
            spec_access     = rw;
            reset           = 0x0;
            reset_mask      = 0x1;
            spec_sw_default = 0x0;
            sw_default_mask = 0x0;
        } ERR50[18:18];
        ERR50->desc="
////1'b1 -> Error_50_pulse[1:0] for ECC DED Error from on-chip SRAM/Fifo from <NV_DLA>.<SDP>.<B2> was equal to 2'b10.
////1'b0 -> Error_50_pulse[1:0] for ECC DED Error from on-chip SRAM/Fifo from <NV_DLA>.<SDP>.<B2> was equal to 2'b01.
";
        field {
            sw              = rw;
            hw              = r;
            spec_access     = rw;
            reset           = 0x0;
            reset_mask      = 0x1;
            spec_sw_default = 0x0;
            sw_default_mask = 0x0;
        } ERR49[17:17];
        ERR49->desc="
////1'b1 -> Error_49_pulse[1:0] for ECC SEC Error from on-chip SRAM/Fifo from <NV_DLA>.<SDP>.<B2> was equal to 2'b10.
////1'b0 -> Error_49_pulse[1:0] for ECC SEC Error from on-chip SRAM/Fifo from <NV_DLA>.<SDP>.<B2> was equal to 2'b01.
";
        field {
            sw              = rw;
            hw              = r;
            spec_access     = rw;
            reset           = 0x0;
            reset_mask      = 0x1;
            spec_sw_default = 0x0;
            sw_default_mask = 0x0;
        } ERR48[16:16];
        ERR48->desc="
////1'b1 -> Error_48_pulse[1:0] for ECC DED Error from on-chip SRAM/Fifo from <NV_DLA>.<SDP> was equal to 2'b10.
////1'b0 -> Error_48_pulse[1:0] for ECC DED Error from on-chip SRAM/Fifo from <NV_DLA>.<SDP> was equal to 2'b01.
";
        field {
            sw              = rw;
            hw              = r;
            spec_access     = rw;
            reset           = 0x0;
            reset_mask      = 0x1;
            spec_sw_default = 0x0;
            sw_default_mask = 0x0;
        } ERR47[15:15];
        ERR47->desc="
////1'b1 -> Error_47_pulse[1:0] for ECC SEC Error from on-chip SRAM/Fifo from <NV_DLA>.<SDP> was equal to 2'b10.
////1'b0 -> Error_47_pulse[1:0] for ECC SEC Error from on-chip SRAM/Fifo from <NV_DLA>.<SDP> was equal to 2'b01.
";
        field {
            sw              = rw;
            hw              = r;
            spec_access     = rw;
            reset           = 0x0;
            reset_mask      = 0x1;
            spec_sw_default = 0x0;
            sw_default_mask = 0x0;
        } ERR46[14:14];
        ERR46->desc="
////1'b1 -> Error_46_pulse[1:0] for ECC DED Error from on-chip SRAM/Fifo from <NV_DLA>.<CACC>.<D7BUF> was equal to 2'b10.
////1'b0 -> Error_46_pulse[1:0] for ECC DED Error from on-chip SRAM/Fifo from <NV_DLA>.<CACC>.<D7BUF> was equal to 2'b01.
";
        field {
            sw              = rw;
            hw              = r;
            spec_access     = rw;
            reset           = 0x0;
            reset_mask      = 0x1;
            spec_sw_default = 0x0;
            sw_default_mask = 0x0;
        } ERR45[13:13];
        ERR45->desc="
////1'b1 -> Error_45_pulse[1:0] for ECC SEC Error from on-chip SRAM/Fifo from <NV_DLA>.<CACC>.<D7BUF> was equal to 2'b10.
////1'b0 -> Error_45_pulse[1:0] for ECC SEC Error from on-chip SRAM/Fifo from <NV_DLA>.<CACC>.<D7BUF> was equal to 2'b01.
";
        field {
            sw              = rw;
            hw              = r;
            spec_access     = rw;
            reset           = 0x0;
            reset_mask      = 0x1;
            spec_sw_default = 0x0;
            sw_default_mask = 0x0;
        } ERR44[12:12];
        ERR44->desc="
////1'b1 -> Error_44_pulse[1:0] for ECC DED Error from on-chip SRAM/Fifo from <NV_DLA>.<CACC>.<D6BUF> was equal to 2'b10.
////1'b0 -> Error_44_pulse[1:0] for ECC DED Error from on-chip SRAM/Fifo from <NV_DLA>.<CACC>.<D6BUF> was equal to 2'b01.
";
        field {
            sw              = rw;
            hw              = r;
            spec_access     = rw;
            reset           = 0x0;
            reset_mask      = 0x1;
            spec_sw_default = 0x0;
            sw_default_mask = 0x0;
        } ERR43[11:11];
        ERR43->desc="
////1'b1 -> Error_43_pulse[1:0] for ECC SEC Error from on-chip SRAM/Fifo from <NV_DLA>.<CACC>.<D6BUF> was equal to 2'b10.
////1'b0 -> Error_43_pulse[1:0] for ECC SEC Error from on-chip SRAM/Fifo from <NV_DLA>.<CACC>.<D6BUF> was equal to 2'b01.
";
        field {
            sw              = rw;
            hw              = r;
            spec_access     = rw;
            reset           = 0x0;
            reset_mask      = 0x1;
            spec_sw_default = 0x0;
            sw_default_mask = 0x0;
        } ERR42[10:10];
        ERR42->desc="
////1'b1 -> Error_42_pulse[1:0] for ECC DED Error from on-chip SRAM/Fifo from <NV_DLA>.<CACC>.<D5BUF> was equal to 2'b10.
////1'b0 -> Error_42_pulse[1:0] for ECC DED Error from on-chip SRAM/Fifo from <NV_DLA>.<CACC>.<D5BUF> was equal to 2'b01.
";
        field {
            sw              = rw;
            hw              = r;
            spec_access     = rw;
            reset           = 0x0;
            reset_mask      = 0x1;
            spec_sw_default = 0x0;
            sw_default_mask = 0x0;
        } ERR41[9:9];
        ERR41->desc="
////1'b1 -> Error_41_pulse[1:0] for ECC SEC Error from on-chip SRAM/Fifo from <NV_DLA>.<CACC>.<D5BUF> was equal to 2'b10.
////1'b0 -> Error_41_pulse[1:0] for ECC SEC Error from on-chip SRAM/Fifo from <NV_DLA>.<CACC>.<D5BUF> was equal to 2'b01.
";
        field {
            sw              = rw;
            hw              = r;
            spec_access     = rw;
            reset           = 0x0;
            reset_mask      = 0x1;
            spec_sw_default = 0x0;
            sw_default_mask = 0x0;
        } ERR40[8:8];
        ERR40->desc="
////1'b1 -> Error_40_pulse[1:0] for ECC DED Error from on-chip SRAM/Fifo from <NV_DLA>.<CACC>.<D4BUF> was equal to 2'b10.
////1'b0 -> Error_40_pulse[1:0] for ECC DED Error from on-chip SRAM/Fifo from <NV_DLA>.<CACC>.<D4BUF> was equal to 2'b01.
";
        field {
            sw              = rw;
            hw              = r;
            spec_access     = rw;
            reset           = 0x0;
            reset_mask      = 0x1;
            spec_sw_default = 0x0;
            sw_default_mask = 0x0;
        } ERR39[7:7];
        ERR39->desc="
////1'b1 -> Error_39_pulse[1:0] for ECC SEC Error from on-chip SRAM/Fifo from <NV_DLA>.<CACC>.<D4BUF> was equal to 2'b10.
////1'b0 -> Error_39_pulse[1:0] for ECC SEC Error from on-chip SRAM/Fifo from <NV_DLA>.<CACC>.<D4BUF> was equal to 2'b01.
";
        field {
            sw              = rw;
            hw              = r;
            spec_access     = rw;
            reset           = 0x0;
            reset_mask      = 0x1;
            spec_sw_default = 0x0;
            sw_default_mask = 0x0;
        } ERR38[6:6];
        ERR38->desc="
////1'b1 -> Error_38_pulse[1:0] for ECC DED Error from on-chip SRAM/Fifo from <NV_DLA>.<CACC>.<D3BUF> was equal to 2'b10.
////1'b0 -> Error_38_pulse[1:0] for ECC DED Error from on-chip SRAM/Fifo from <NV_DLA>.<CACC>.<D3BUF> was equal to 2'b01.
";
        field {
            sw              = rw;
            hw              = r;
            spec_access     = rw;
            reset           = 0x0;
            reset_mask      = 0x1;
            spec_sw_default = 0x0;
            sw_default_mask = 0x0;
        } ERR37[5:5];
        ERR37->desc="
////1'b1 -> Error_37_pulse[1:0] for ECC SEC Error from on-chip SRAM/Fifo from <NV_DLA>.<CACC>.<D3BUF> was equal to 2'b10.
////1'b0 -> Error_37_pulse[1:0] for ECC SEC Error from on-chip SRAM/Fifo from <NV_DLA>.<CACC>.<D3BUF> was equal to 2'b01.
";
        field {
            sw              = rw;
            hw              = r;
            spec_access     = rw;
            reset           = 0x0;
            reset_mask      = 0x1;
            spec_sw_default = 0x0;
            sw_default_mask = 0x0;
        } ERR36[4:4];
        ERR36->desc="
////1'b1 -> Error_36_pulse[1:0] for ECC DED Error from on-chip SRAM/Fifo from <NV_DLA>.<CACC>.<D2BUF> was equal to 2'b10.
////1'b0 -> Error_36_pulse[1:0] for ECC DED Error from on-chip SRAM/Fifo from <NV_DLA>.<CACC>.<D2BUF> was equal to 2'b01.
";
        field {
            sw              = rw;
            hw              = r;
            spec_access     = rw;
            reset           = 0x0;
            reset_mask      = 0x1;
            spec_sw_default = 0x0;
            sw_default_mask = 0x0;
        } ERR35[3:3];
        ERR35->desc="
////1'b1 -> Error_35_pulse[1:0] for ECC SEC Error from on-chip SRAM/Fifo from <NV_DLA>.<CACC>.<D2BUF> was equal to 2'b10.
////1'b0 -> Error_35_pulse[1:0] for ECC SEC Error from on-chip SRAM/Fifo from <NV_DLA>.<CACC>.<D2BUF> was equal to 2'b01.
";
        field {
            sw              = rw;
            hw              = r;
            spec_access     = rw;
            reset           = 0x0;
            reset_mask      = 0x1;
            spec_sw_default = 0x0;
            sw_default_mask = 0x0;
        } ERR34[2:2];
        ERR34->desc="
////1'b1 -> Error_34_pulse[1:0] for ECC DED Error from on-chip SRAM/Fifo from <NV_DLA>.<CACC>.<D1BUF> was equal to 2'b10.
////1'b0 -> Error_34_pulse[1:0] for ECC DED Error from on-chip SRAM/Fifo from <NV_DLA>.<CACC>.<D1BUF> was equal to 2'b01.
";
        field {
            sw              = rw;
            hw              = r;
            spec_access     = rw;
            reset           = 0x0;
            reset_mask      = 0x1;
            spec_sw_default = 0x0;
            sw_default_mask = 0x0;
        } ERR33[1:1];
        ERR33->desc="
////1'b1 -> Error_33_pulse[1:0] for ECC SEC Error from on-chip SRAM/Fifo from <NV_DLA>.<CACC>.<D1BUF> was equal to 2'b10.
////1'b0 -> Error_33_pulse[1:0] for ECC SEC Error from on-chip SRAM/Fifo from <NV_DLA>.<CACC>.<D1BUF> was equal to 2'b01.
";
        field {
            sw              = rw;
            hw              = r;
            spec_access     = rw;
            reset           = 0x0;
            reset_mask      = 0x1;
            spec_sw_default = 0x0;
            sw_default_mask = 0x0;
        } ERR32[0:0];
        ERR32->desc="
////1'b1 -> Error_32_pulse[1:0] for ECC DED Error from on-chip SRAM/Fifo from <NV_DLA>.<CACC>.<D0BUF> was equal to 2'b10.
////1'b0 -> Error_32_pulse[1:0] for ECC DED Error from on-chip SRAM/Fifo from <NV_DLA>.<CACC>.<D0BUF> was equal to 2'b01.
";
    }ERRSLICE1_MISSIONERR_STATUS @0x68;
    reg {
        name = "ERRSLICE1_MISSIONERR_INJECT";
        enum ERRSLICE1_MISSIONERR_INJECT_ERR63_enum {
            DISABLE = 1'd0;
            ENABLE = 1'd1;
        };
        field {
            encode          = ERRSLICE1_MISSIONERR_INJECT_ERR63_enum;
            sw              = rw;
            hw              = r;
            spec_access     = rw;
            reset           = 0x0;
            reset_mask      = 0x1;
            spec_sw_default = 0x0;
            sw_default_mask = 0x0;
        } ERR63[31:31];
        ERR63->desc="
////1'b1 -> Assert the inject_error_63 output for ECC SEC Error from on-chip SRAM/Fifo to <NV_DLA>.<FALCON>.<IMEM> to allow for error injection.
////1'b0 -> De-Asseert inject_error_63 output.
";
        enum ERRSLICE1_MISSIONERR_INJECT_ERR62_enum {
            DISABLE = 1'd0;
            ENABLE = 1'd1;
        };
        field {
            encode          = ERRSLICE1_MISSIONERR_INJECT_ERR62_enum;
            sw              = rw;
            hw              = r;
            spec_access     = rw;
            reset           = 0x0;
            reset_mask      = 0x1;
            spec_sw_default = 0x0;
            sw_default_mask = 0x0;
        } ERR62[30:30];
        ERR62->desc="
////1'b1 -> Assert the inject_error_62 output for ECC DED Error from on-chip SRAM/Fifo to <NV_DLA>.<RUBIK>.<FIFO_B> to allow for error injection.
////1'b0 -> De-Asseert inject_error_62 output.
";
        enum ERRSLICE1_MISSIONERR_INJECT_ERR61_enum {
            DISABLE = 1'd0;
            ENABLE = 1'd1;
        };
        field {
            encode          = ERRSLICE1_MISSIONERR_INJECT_ERR61_enum;
            sw              = rw;
            hw              = r;
            spec_access     = rw;
            reset           = 0x0;
            reset_mask      = 0x1;
            spec_sw_default = 0x0;
            sw_default_mask = 0x0;
        } ERR61[29:29];
        ERR61->desc="
////1'b1 -> Assert the inject_error_61 output for ECC SEC Error from on-chip SRAM/Fifo to <NV_DLA>.<RUBIK>.<FIFO_B> to allow for error injection.
////1'b0 -> De-Asseert inject_error_61 output.
";
        enum ERRSLICE1_MISSIONERR_INJECT_ERR60_enum {
            DISABLE = 1'd0;
            ENABLE = 1'd1;
        };
        field {
            encode          = ERRSLICE1_MISSIONERR_INJECT_ERR60_enum;
            sw              = rw;
            hw              = r;
            spec_access     = rw;
            reset           = 0x0;
            reset_mask      = 0x1;
            spec_sw_default = 0x0;
            sw_default_mask = 0x0;
        } ERR60[28:28];
        ERR60->desc="
////1'b1 -> Assert the inject_error_60 output for ECC DED Error from on-chip SRAM/Fifo to <NV_DLA>.<RUBIK>.<FIFO_A> to allow for error injection.
////1'b0 -> De-Asseert inject_error_60 output.
";
        enum ERRSLICE1_MISSIONERR_INJECT_ERR59_enum {
            DISABLE = 1'd0;
            ENABLE = 1'd1;
        };
        field {
            encode          = ERRSLICE1_MISSIONERR_INJECT_ERR59_enum;
            sw              = rw;
            hw              = r;
            spec_access     = rw;
            reset           = 0x0;
            reset_mask      = 0x1;
            spec_sw_default = 0x0;
            sw_default_mask = 0x0;
        } ERR59[27:27];
        ERR59->desc="
////1'b1 -> Assert the inject_error_59 output for ECC SEC Error from on-chip SRAM/Fifo to <NV_DLA>.<RUBIK>.<FIFO_A> to allow for error injection.
////1'b0 -> De-Asseert inject_error_59 output.
";
        enum ERRSLICE1_MISSIONERR_INJECT_ERR58_enum {
            DISABLE = 1'd0;
            ENABLE = 1'd1;
        };
        field {
            encode          = ERRSLICE1_MISSIONERR_INJECT_ERR58_enum;
            sw              = rw;
            hw              = r;
            spec_access     = rw;
            reset           = 0x0;
            reset_mask      = 0x1;
            spec_sw_default = 0x0;
            sw_default_mask = 0x0;
        } ERR58[26:26];
        ERR58->desc="
////1'b1 -> Assert the inject_error_58 output for ECC DED Error from on-chip SRAM/Fifo to <NV_DLA>.<CDP> to allow for error injection.
////1'b0 -> De-Asseert inject_error_58 output.
";
        enum ERRSLICE1_MISSIONERR_INJECT_ERR57_enum {
            DISABLE = 1'd0;
            ENABLE = 1'd1;
        };
        field {
            encode          = ERRSLICE1_MISSIONERR_INJECT_ERR57_enum;
            sw              = rw;
            hw              = r;
            spec_access     = rw;
            reset           = 0x0;
            reset_mask      = 0x1;
            spec_sw_default = 0x0;
            sw_default_mask = 0x0;
        } ERR57[25:25];
        ERR57->desc="
////1'b1 -> Assert the inject_error_57 output for ECC SEC Error from on-chip SRAM/Fifo to <NV_DLA>.<CDP> to allow for error injection.
////1'b0 -> De-Asseert inject_error_57 output.
";
        enum ERRSLICE1_MISSIONERR_INJECT_ERR56_enum {
            DISABLE = 1'd0;
            ENABLE = 1'd1;
        };
        field {
            encode          = ERRSLICE1_MISSIONERR_INJECT_ERR56_enum;
            sw              = rw;
            hw              = r;
            spec_access     = rw;
            reset           = 0x0;
            reset_mask      = 0x1;
            spec_sw_default = 0x0;
            sw_default_mask = 0x0;
        } ERR56[24:24];
        ERR56->desc="
////1'b1 -> Assert the inject_error_56 output for ECC DED Error from on-chip SRAM/Fifo to <NV_DLA>.<PDP> to allow for error injection.
////1'b0 -> De-Asseert inject_error_56 output.
";
        enum ERRSLICE1_MISSIONERR_INJECT_ERR55_enum {
            DISABLE = 1'd0;
            ENABLE = 1'd1;
        };
        field {
            encode          = ERRSLICE1_MISSIONERR_INJECT_ERR55_enum;
            sw              = rw;
            hw              = r;
            spec_access     = rw;
            reset           = 0x0;
            reset_mask      = 0x1;
            spec_sw_default = 0x0;
            sw_default_mask = 0x0;
        } ERR55[23:23];
        ERR55->desc="
////1'b1 -> Assert the inject_error_55 output for ECC SEC Error from on-chip SRAM/Fifo to <NV_DLA>.<PDP> to allow for error injection.
////1'b0 -> De-Asseert inject_error_55 output.
";
        enum ERRSLICE1_MISSIONERR_INJECT_ERR54_enum {
            DISABLE = 1'd0;
            ENABLE = 1'd1;
        };
        field {
            encode          = ERRSLICE1_MISSIONERR_INJECT_ERR54_enum;
            sw              = rw;
            hw              = r;
            spec_access     = rw;
            reset           = 0x0;
            reset_mask      = 0x1;
            spec_sw_default = 0x0;
            sw_default_mask = 0x0;
        } ERR54[22:22];
        ERR54->desc="
////1'b1 -> Assert the inject_error_54 output for ECC DED Error from on-chip SRAM/Fifo to <NV_DLA>.<SDP>.<E2> to allow for error injection.
////1'b0 -> De-Asseert inject_error_54 output.
";
        enum ERRSLICE1_MISSIONERR_INJECT_ERR53_enum {
            DISABLE = 1'd0;
            ENABLE = 1'd1;
        };
        field {
            encode          = ERRSLICE1_MISSIONERR_INJECT_ERR53_enum;
            sw              = rw;
            hw              = r;
            spec_access     = rw;
            reset           = 0x0;
            reset_mask      = 0x1;
            spec_sw_default = 0x0;
            sw_default_mask = 0x0;
        } ERR53[21:21];
        ERR53->desc="
////1'b1 -> Assert the inject_error_53 output for ECC SEC Error from on-chip SRAM/Fifo to <NV_DLA>.<SDP>.<E2> to allow for error injection.
////1'b0 -> De-Asseert inject_error_53 output.
";
        enum ERRSLICE1_MISSIONERR_INJECT_ERR52_enum {
            DISABLE = 1'd0;
            ENABLE = 1'd1;
        };
        field {
            encode          = ERRSLICE1_MISSIONERR_INJECT_ERR52_enum;
            sw              = rw;
            hw              = r;
            spec_access     = rw;
            reset           = 0x0;
            reset_mask      = 0x1;
            spec_sw_default = 0x0;
            sw_default_mask = 0x0;
        } ERR52[20:20];
        ERR52->desc="
////1'b1 -> Assert the inject_error_52 output for ECC DED Error from on-chip SRAM/Fifo to <NV_DLA>.<SDP>.<N2> to allow for error injection.
////1'b0 -> De-Asseert inject_error_52 output.
";
        enum ERRSLICE1_MISSIONERR_INJECT_ERR51_enum {
            DISABLE = 1'd0;
            ENABLE = 1'd1;
        };
        field {
            encode          = ERRSLICE1_MISSIONERR_INJECT_ERR51_enum;
            sw              = rw;
            hw              = r;
            spec_access     = rw;
            reset           = 0x0;
            reset_mask      = 0x1;
            spec_sw_default = 0x0;
            sw_default_mask = 0x0;
        } ERR51[19:19];
        ERR51->desc="
////1'b1 -> Assert the inject_error_51 output for ECC SEC Error from on-chip SRAM/Fifo to <NV_DLA>.<SDP>.<N2> to allow for error injection.
////1'b0 -> De-Asseert inject_error_51 output.
";
        enum ERRSLICE1_MISSIONERR_INJECT_ERR50_enum {
            DISABLE = 1'd0;
            ENABLE = 1'd1;
        };
        field {
            encode          = ERRSLICE1_MISSIONERR_INJECT_ERR50_enum;
            sw              = rw;
            hw              = r;
            spec_access     = rw;
            reset           = 0x0;
            reset_mask      = 0x1;
            spec_sw_default = 0x0;
            sw_default_mask = 0x0;
        } ERR50[18:18];
        ERR50->desc="
////1'b1 -> Assert the inject_error_50 output for ECC DED Error from on-chip SRAM/Fifo to <NV_DLA>.<SDP>.<B2> to allow for error injection.
////1'b0 -> De-Asseert inject_error_50 output.
";
        enum ERRSLICE1_MISSIONERR_INJECT_ERR49_enum {
            DISABLE = 1'd0;
            ENABLE = 1'd1;
        };
        field {
            encode          = ERRSLICE1_MISSIONERR_INJECT_ERR49_enum;
            sw              = rw;
            hw              = r;
            spec_access     = rw;
            reset           = 0x0;
            reset_mask      = 0x1;
            spec_sw_default = 0x0;
            sw_default_mask = 0x0;
        } ERR49[17:17];
        ERR49->desc="
////1'b1 -> Assert the inject_error_49 output for ECC SEC Error from on-chip SRAM/Fifo to <NV_DLA>.<SDP>.<B2> to allow for error injection.
////1'b0 -> De-Asseert inject_error_49 output.
";
        enum ERRSLICE1_MISSIONERR_INJECT_ERR48_enum {
            DISABLE = 1'd0;
            ENABLE = 1'd1;
        };
        field {
            encode          = ERRSLICE1_MISSIONERR_INJECT_ERR48_enum;
            sw              = rw;
            hw              = r;
            spec_access     = rw;
            reset           = 0x0;
            reset_mask      = 0x1;
            spec_sw_default = 0x0;
            sw_default_mask = 0x0;
        } ERR48[16:16];
        ERR48->desc="
////1'b1 -> Assert the inject_error_48 output for ECC DED Error from on-chip SRAM/Fifo to <NV_DLA>.<SDP> to allow for error injection.
////1'b0 -> De-Asseert inject_error_48 output.
";
        enum ERRSLICE1_MISSIONERR_INJECT_ERR47_enum {
            DISABLE = 1'd0;
            ENABLE = 1'd1;
        };
        field {
            encode          = ERRSLICE1_MISSIONERR_INJECT_ERR47_enum;
            sw              = rw;
            hw              = r;
            spec_access     = rw;
            reset           = 0x0;
            reset_mask      = 0x1;
            spec_sw_default = 0x0;
            sw_default_mask = 0x0;
        } ERR47[15:15];
        ERR47->desc="
////1'b1 -> Assert the inject_error_47 output for ECC SEC Error from on-chip SRAM/Fifo to <NV_DLA>.<SDP> to allow for error injection.
////1'b0 -> De-Asseert inject_error_47 output.
";
        enum ERRSLICE1_MISSIONERR_INJECT_ERR46_enum {
            DISABLE = 1'd0;
            ENABLE = 1'd1;
        };
        field {
            encode          = ERRSLICE1_MISSIONERR_INJECT_ERR46_enum;
            sw              = rw;
            hw              = r;
            spec_access     = rw;
            reset           = 0x0;
            reset_mask      = 0x1;
            spec_sw_default = 0x0;
            sw_default_mask = 0x0;
        } ERR46[14:14];
        ERR46->desc="
////1'b1 -> Assert the inject_error_46 output for ECC DED Error from on-chip SRAM/Fifo to <NV_DLA>.<CACC>.<D7BUF> to allow for error injection.
////1'b0 -> De-Asseert inject_error_46 output.
";
        enum ERRSLICE1_MISSIONERR_INJECT_ERR45_enum {
            DISABLE = 1'd0;
            ENABLE = 1'd1;
        };
        field {
            encode          = ERRSLICE1_MISSIONERR_INJECT_ERR45_enum;
            sw              = rw;
            hw              = r;
            spec_access     = rw;
            reset           = 0x0;
            reset_mask      = 0x1;
            spec_sw_default = 0x0;
            sw_default_mask = 0x0;
        } ERR45[13:13];
        ERR45->desc="
////1'b1 -> Assert the inject_error_45 output for ECC SEC Error from on-chip SRAM/Fifo to <NV_DLA>.<CACC>.<D7BUF> to allow for error injection.
////1'b0 -> De-Asseert inject_error_45 output.
";
        enum ERRSLICE1_MISSIONERR_INJECT_ERR44_enum {
            DISABLE = 1'd0;
            ENABLE = 1'd1;
        };
        field {
            encode          = ERRSLICE1_MISSIONERR_INJECT_ERR44_enum;
            sw              = rw;
            hw              = r;
            spec_access     = rw;
            reset           = 0x0;
            reset_mask      = 0x1;
            spec_sw_default = 0x0;
            sw_default_mask = 0x0;
        } ERR44[12:12];
        ERR44->desc="
////1'b1 -> Assert the inject_error_44 output for ECC DED Error from on-chip SRAM/Fifo to <NV_DLA>.<CACC>.<D6BUF> to allow for error injection.
////1'b0 -> De-Asseert inject_error_44 output.
";
        enum ERRSLICE1_MISSIONERR_INJECT_ERR43_enum {
            DISABLE = 1'd0;
            ENABLE = 1'd1;
        };
        field {
            encode          = ERRSLICE1_MISSIONERR_INJECT_ERR43_enum;
            sw              = rw;
            hw              = r;
            spec_access     = rw;
            reset           = 0x0;
            reset_mask      = 0x1;
            spec_sw_default = 0x0;
            sw_default_mask = 0x0;
        } ERR43[11:11];
        ERR43->desc="
////1'b1 -> Assert the inject_error_43 output for ECC SEC Error from on-chip SRAM/Fifo to <NV_DLA>.<CACC>.<D6BUF> to allow for error injection.
////1'b0 -> De-Asseert inject_error_43 output.
";
        enum ERRSLICE1_MISSIONERR_INJECT_ERR42_enum {
            DISABLE = 1'd0;
            ENABLE = 1'd1;
        };
        field {
            encode          = ERRSLICE1_MISSIONERR_INJECT_ERR42_enum;
            sw              = rw;
            hw              = r;
            spec_access     = rw;
            reset           = 0x0;
            reset_mask      = 0x1;
            spec_sw_default = 0x0;
            sw_default_mask = 0x0;
        } ERR42[10:10];
        ERR42->desc="
////1'b1 -> Assert the inject_error_42 output for ECC DED Error from on-chip SRAM/Fifo to <NV_DLA>.<CACC>.<D5BUF> to allow for error injection.
////1'b0 -> De-Asseert inject_error_42 output.
";
        enum ERRSLICE1_MISSIONERR_INJECT_ERR41_enum {
            DISABLE = 1'd0;
            ENABLE = 1'd1;
        };
        field {
            encode          = ERRSLICE1_MISSIONERR_INJECT_ERR41_enum;
            sw              = rw;
            hw              = r;
            spec_access     = rw;
            reset           = 0x0;
            reset_mask      = 0x1;
            spec_sw_default = 0x0;
            sw_default_mask = 0x0;
        } ERR41[9:9];
        ERR41->desc="
////1'b1 -> Assert the inject_error_41 output for ECC SEC Error from on-chip SRAM/Fifo to <NV_DLA>.<CACC>.<D5BUF> to allow for error injection.
////1'b0 -> De-Asseert inject_error_41 output.
";
        enum ERRSLICE1_MISSIONERR_INJECT_ERR40_enum {
            DISABLE = 1'd0;
            ENABLE = 1'd1;
        };
        field {
            encode          = ERRSLICE1_MISSIONERR_INJECT_ERR40_enum;
            sw              = rw;
            hw              = r;
            spec_access     = rw;
            reset           = 0x0;
            reset_mask      = 0x1;
            spec_sw_default = 0x0;
            sw_default_mask = 0x0;
        } ERR40[8:8];
        ERR40->desc="
////1'b1 -> Assert the inject_error_40 output for ECC DED Error from on-chip SRAM/Fifo to <NV_DLA>.<CACC>.<D4BUF> to allow for error injection.
////1'b0 -> De-Asseert inject_error_40 output.
";
        enum ERRSLICE1_MISSIONERR_INJECT_ERR39_enum {
            DISABLE = 1'd0;
            ENABLE = 1'd1;
        };
        field {
            encode          = ERRSLICE1_MISSIONERR_INJECT_ERR39_enum;
            sw              = rw;
            hw              = r;
            spec_access     = rw;
            reset           = 0x0;
            reset_mask      = 0x1;
            spec_sw_default = 0x0;
            sw_default_mask = 0x0;
        } ERR39[7:7];
        ERR39->desc="
////1'b1 -> Assert the inject_error_39 output for ECC SEC Error from on-chip SRAM/Fifo to <NV_DLA>.<CACC>.<D4BUF> to allow for error injection.
////1'b0 -> De-Asseert inject_error_39 output.
";
        enum ERRSLICE1_MISSIONERR_INJECT_ERR38_enum {
            DISABLE = 1'd0;
            ENABLE = 1'd1;
        };
        field {
            encode          = ERRSLICE1_MISSIONERR_INJECT_ERR38_enum;
            sw              = rw;
            hw              = r;
            spec_access     = rw;
            reset           = 0x0;
            reset_mask      = 0x1;
            spec_sw_default = 0x0;
            sw_default_mask = 0x0;
        } ERR38[6:6];
        ERR38->desc="
////1'b1 -> Assert the inject_error_38 output for ECC DED Error from on-chip SRAM/Fifo to <NV_DLA>.<CACC>.<D3BUF> to allow for error injection.
////1'b0 -> De-Asseert inject_error_38 output.
";
        enum ERRSLICE1_MISSIONERR_INJECT_ERR37_enum {
            DISABLE = 1'd0;
            ENABLE = 1'd1;
        };
        field {
            encode          = ERRSLICE1_MISSIONERR_INJECT_ERR37_enum;
            sw              = rw;
            hw              = r;
            spec_access     = rw;
            reset           = 0x0;
            reset_mask      = 0x1;
            spec_sw_default = 0x0;
            sw_default_mask = 0x0;
        } ERR37[5:5];
        ERR37->desc="
////1'b1 -> Assert the inject_error_37 output for ECC SEC Error from on-chip SRAM/Fifo to <NV_DLA>.<CACC>.<D3BUF> to allow for error injection.
////1'b0 -> De-Asseert inject_error_37 output.
";
        enum ERRSLICE1_MISSIONERR_INJECT_ERR36_enum {
            DISABLE = 1'd0;
            ENABLE = 1'd1;
        };
        field {
            encode          = ERRSLICE1_MISSIONERR_INJECT_ERR36_enum;
            sw              = rw;
            hw              = r;
            spec_access     = rw;
            reset           = 0x0;
            reset_mask      = 0x1;
            spec_sw_default = 0x0;
            sw_default_mask = 0x0;
        } ERR36[4:4];
        ERR36->desc="
////1'b1 -> Assert the inject_error_36 output for ECC DED Error from on-chip SRAM/Fifo to <NV_DLA>.<CACC>.<D2BUF> to allow for error injection.
////1'b0 -> De-Asseert inject_error_36 output.
";
        enum ERRSLICE1_MISSIONERR_INJECT_ERR35_enum {
            DISABLE = 1'd0;
            ENABLE = 1'd1;
        };
        field {
            encode          = ERRSLICE1_MISSIONERR_INJECT_ERR35_enum;
            sw              = rw;
            hw              = r;
            spec_access     = rw;
            reset           = 0x0;
            reset_mask      = 0x1;
            spec_sw_default = 0x0;
            sw_default_mask = 0x0;
        } ERR35[3:3];
        ERR35->desc="
////1'b1 -> Assert the inject_error_35 output for ECC SEC Error from on-chip SRAM/Fifo to <NV_DLA>.<CACC>.<D2BUF> to allow for error injection.
////1'b0 -> De-Asseert inject_error_35 output.
";
        enum ERRSLICE1_MISSIONERR_INJECT_ERR34_enum {
            DISABLE = 1'd0;
            ENABLE = 1'd1;
        };
        field {
            encode          = ERRSLICE1_MISSIONERR_INJECT_ERR34_enum;
            sw              = rw;
            hw              = r;
            spec_access     = rw;
            reset           = 0x0;
            reset_mask      = 0x1;
            spec_sw_default = 0x0;
            sw_default_mask = 0x0;
        } ERR34[2:2];
        ERR34->desc="
////1'b1 -> Assert the inject_error_34 output for ECC DED Error from on-chip SRAM/Fifo to <NV_DLA>.<CACC>.<D1BUF> to allow for error injection.
////1'b0 -> De-Asseert inject_error_34 output.
";
        enum ERRSLICE1_MISSIONERR_INJECT_ERR33_enum {
            DISABLE = 1'd0;
            ENABLE = 1'd1;
        };
        field {
            encode          = ERRSLICE1_MISSIONERR_INJECT_ERR33_enum;
            sw              = rw;
            hw              = r;
            spec_access     = rw;
            reset           = 0x0;
            reset_mask      = 0x1;
            spec_sw_default = 0x0;
            sw_default_mask = 0x0;
        } ERR33[1:1];
        ERR33->desc="
////1'b1 -> Assert the inject_error_33 output for ECC SEC Error from on-chip SRAM/Fifo to <NV_DLA>.<CACC>.<D1BUF> to allow for error injection.
////1'b0 -> De-Asseert inject_error_33 output.
";
        enum ERRSLICE1_MISSIONERR_INJECT_ERR32_enum {
            DISABLE = 1'd0;
            ENABLE = 1'd1;
        };
        field {
            encode          = ERRSLICE1_MISSIONERR_INJECT_ERR32_enum;
            sw              = rw;
            hw              = r;
            spec_access     = rw;
            reset           = 0x0;
            reset_mask      = 0x1;
            spec_sw_default = 0x0;
            sw_default_mask = 0x0;
        } ERR32[0:0];
        ERR32->desc="
////1'b1 -> Assert the inject_error_32 output for ECC DED Error from on-chip SRAM/Fifo to <NV_DLA>.<CACC>.<D0BUF> to allow for error injection.
////1'b0 -> De-Asseert inject_error_32 output.
";
    }ERRSLICE1_MISSIONERR_INJECT @0x6c;
    reg {
        name = "ERRSLICE1_LATENTERR_ENABLE";
        enum ERRSLICE1_LATENTERR_ENABLE_ERR63_enum {
            DISABLE = 1'd0;
            ENABLE = 1'd1;
        };
        field {
            encode          = ERRSLICE1_LATENTERR_ENABLE_ERR63_enum;
            sw              = rw;
            hw              = r;
            spec_access     = rw;
            reset           = 0x1;
            reset_mask      = 0x1;
            spec_sw_default = 0x0;
            sw_default_mask = 0x0;
        } ERR63[31:31];
        ERR63->desc="
////1'b1 -> Enable  Latent Error Reporting for ECC SEC Error from on-chip SRAM/Fifo from <NV_DLA>.<FALCON>.<IMEM>
////1'b0 -> Disable Latent Error Reporting for ECC SEC Error from on-chip SRAM/Fifo from <NV_DLA>.<FALCON>.<IMEM>
";
        enum ERRSLICE1_LATENTERR_ENABLE_ERR62_enum {
            DISABLE = 1'd0;
            ENABLE = 1'd1;
        };
        field {
            encode          = ERRSLICE1_LATENTERR_ENABLE_ERR62_enum;
            sw              = rw;
            hw              = r;
            spec_access     = rw;
            reset           = 0x1;
            reset_mask      = 0x1;
            spec_sw_default = 0x0;
            sw_default_mask = 0x0;
        } ERR62[30:30];
        ERR62->desc="
////1'b1 -> Enable  Latent Error Reporting for ECC DED Error from on-chip SRAM/Fifo from <NV_DLA>.<RUBIK>.<FIFO_B>
////1'b0 -> Disable Latent Error Reporting for ECC DED Error from on-chip SRAM/Fifo from <NV_DLA>.<RUBIK>.<FIFO_B>
";
        enum ERRSLICE1_LATENTERR_ENABLE_ERR61_enum {
            DISABLE = 1'd0;
            ENABLE = 1'd1;
        };
        field {
            encode          = ERRSLICE1_LATENTERR_ENABLE_ERR61_enum;
            sw              = rw;
            hw              = r;
            spec_access     = rw;
            reset           = 0x1;
            reset_mask      = 0x1;
            spec_sw_default = 0x0;
            sw_default_mask = 0x0;
        } ERR61[29:29];
        ERR61->desc="
////1'b1 -> Enable  Latent Error Reporting for ECC SEC Error from on-chip SRAM/Fifo from <NV_DLA>.<RUBIK>.<FIFO_B>
////1'b0 -> Disable Latent Error Reporting for ECC SEC Error from on-chip SRAM/Fifo from <NV_DLA>.<RUBIK>.<FIFO_B>
";
        enum ERRSLICE1_LATENTERR_ENABLE_ERR60_enum {
            DISABLE = 1'd0;
            ENABLE = 1'd1;
        };
        field {
            encode          = ERRSLICE1_LATENTERR_ENABLE_ERR60_enum;
            sw              = rw;
            hw              = r;
            spec_access     = rw;
            reset           = 0x1;
            reset_mask      = 0x1;
            spec_sw_default = 0x0;
            sw_default_mask = 0x0;
        } ERR60[28:28];
        ERR60->desc="
////1'b1 -> Enable  Latent Error Reporting for ECC DED Error from on-chip SRAM/Fifo from <NV_DLA>.<RUBIK>.<FIFO_A>
////1'b0 -> Disable Latent Error Reporting for ECC DED Error from on-chip SRAM/Fifo from <NV_DLA>.<RUBIK>.<FIFO_A>
";
        enum ERRSLICE1_LATENTERR_ENABLE_ERR59_enum {
            DISABLE = 1'd0;
            ENABLE = 1'd1;
        };
        field {
            encode          = ERRSLICE1_LATENTERR_ENABLE_ERR59_enum;
            sw              = rw;
            hw              = r;
            spec_access     = rw;
            reset           = 0x1;
            reset_mask      = 0x1;
            spec_sw_default = 0x0;
            sw_default_mask = 0x0;
        } ERR59[27:27];
        ERR59->desc="
////1'b1 -> Enable  Latent Error Reporting for ECC SEC Error from on-chip SRAM/Fifo from <NV_DLA>.<RUBIK>.<FIFO_A>
////1'b0 -> Disable Latent Error Reporting for ECC SEC Error from on-chip SRAM/Fifo from <NV_DLA>.<RUBIK>.<FIFO_A>
";
        enum ERRSLICE1_LATENTERR_ENABLE_ERR58_enum {
            DISABLE = 1'd0;
            ENABLE = 1'd1;
        };
        field {
            encode          = ERRSLICE1_LATENTERR_ENABLE_ERR58_enum;
            sw              = rw;
            hw              = r;
            spec_access     = rw;
            reset           = 0x1;
            reset_mask      = 0x1;
            spec_sw_default = 0x0;
            sw_default_mask = 0x0;
        } ERR58[26:26];
        ERR58->desc="
////1'b1 -> Enable  Latent Error Reporting for ECC DED Error from on-chip SRAM/Fifo from <NV_DLA>.<CDP>
////1'b0 -> Disable Latent Error Reporting for ECC DED Error from on-chip SRAM/Fifo from <NV_DLA>.<CDP>
";
        enum ERRSLICE1_LATENTERR_ENABLE_ERR57_enum {
            DISABLE = 1'd0;
            ENABLE = 1'd1;
        };
        field {
            encode          = ERRSLICE1_LATENTERR_ENABLE_ERR57_enum;
            sw              = rw;
            hw              = r;
            spec_access     = rw;
            reset           = 0x1;
            reset_mask      = 0x1;
            spec_sw_default = 0x0;
            sw_default_mask = 0x0;
        } ERR57[25:25];
        ERR57->desc="
////1'b1 -> Enable  Latent Error Reporting for ECC SEC Error from on-chip SRAM/Fifo from <NV_DLA>.<CDP>
////1'b0 -> Disable Latent Error Reporting for ECC SEC Error from on-chip SRAM/Fifo from <NV_DLA>.<CDP>
";
        enum ERRSLICE1_LATENTERR_ENABLE_ERR56_enum {
            DISABLE = 1'd0;
            ENABLE = 1'd1;
        };
        field {
            encode          = ERRSLICE1_LATENTERR_ENABLE_ERR56_enum;
            sw              = rw;
            hw              = r;
            spec_access     = rw;
            reset           = 0x1;
            reset_mask      = 0x1;
            spec_sw_default = 0x0;
            sw_default_mask = 0x0;
        } ERR56[24:24];
        ERR56->desc="
////1'b1 -> Enable  Latent Error Reporting for ECC DED Error from on-chip SRAM/Fifo from <NV_DLA>.<PDP>
////1'b0 -> Disable Latent Error Reporting for ECC DED Error from on-chip SRAM/Fifo from <NV_DLA>.<PDP>
";
        enum ERRSLICE1_LATENTERR_ENABLE_ERR55_enum {
            DISABLE = 1'd0;
            ENABLE = 1'd1;
        };
        field {
            encode          = ERRSLICE1_LATENTERR_ENABLE_ERR55_enum;
            sw              = rw;
            hw              = r;
            spec_access     = rw;
            reset           = 0x1;
            reset_mask      = 0x1;
            spec_sw_default = 0x0;
            sw_default_mask = 0x0;
        } ERR55[23:23];
        ERR55->desc="
////1'b1 -> Enable  Latent Error Reporting for ECC SEC Error from on-chip SRAM/Fifo from <NV_DLA>.<PDP>
////1'b0 -> Disable Latent Error Reporting for ECC SEC Error from on-chip SRAM/Fifo from <NV_DLA>.<PDP>
";
        enum ERRSLICE1_LATENTERR_ENABLE_ERR54_enum {
            DISABLE = 1'd0;
            ENABLE = 1'd1;
        };
        field {
            encode          = ERRSLICE1_LATENTERR_ENABLE_ERR54_enum;
            sw              = rw;
            hw              = r;
            spec_access     = rw;
            reset           = 0x1;
            reset_mask      = 0x1;
            spec_sw_default = 0x0;
            sw_default_mask = 0x0;
        } ERR54[22:22];
        ERR54->desc="
////1'b1 -> Enable  Latent Error Reporting for ECC DED Error from on-chip SRAM/Fifo from <NV_DLA>.<SDP>.<E2>
////1'b0 -> Disable Latent Error Reporting for ECC DED Error from on-chip SRAM/Fifo from <NV_DLA>.<SDP>.<E2>
";
        enum ERRSLICE1_LATENTERR_ENABLE_ERR53_enum {
            DISABLE = 1'd0;
            ENABLE = 1'd1;
        };
        field {
            encode          = ERRSLICE1_LATENTERR_ENABLE_ERR53_enum;
            sw              = rw;
            hw              = r;
            spec_access     = rw;
            reset           = 0x1;
            reset_mask      = 0x1;
            spec_sw_default = 0x0;
            sw_default_mask = 0x0;
        } ERR53[21:21];
        ERR53->desc="
////1'b1 -> Enable  Latent Error Reporting for ECC SEC Error from on-chip SRAM/Fifo from <NV_DLA>.<SDP>.<E2>
////1'b0 -> Disable Latent Error Reporting for ECC SEC Error from on-chip SRAM/Fifo from <NV_DLA>.<SDP>.<E2>
";
        enum ERRSLICE1_LATENTERR_ENABLE_ERR52_enum {
            DISABLE = 1'd0;
            ENABLE = 1'd1;
        };
        field {
            encode          = ERRSLICE1_LATENTERR_ENABLE_ERR52_enum;
            sw              = rw;
            hw              = r;
            spec_access     = rw;
            reset           = 0x1;
            reset_mask      = 0x1;
            spec_sw_default = 0x0;
            sw_default_mask = 0x0;
        } ERR52[20:20];
        ERR52->desc="
////1'b1 -> Enable  Latent Error Reporting for ECC DED Error from on-chip SRAM/Fifo from <NV_DLA>.<SDP>.<N2>
////1'b0 -> Disable Latent Error Reporting for ECC DED Error from on-chip SRAM/Fifo from <NV_DLA>.<SDP>.<N2>
";
        enum ERRSLICE1_LATENTERR_ENABLE_ERR51_enum {
            DISABLE = 1'd0;
            ENABLE = 1'd1;
        };
        field {
            encode          = ERRSLICE1_LATENTERR_ENABLE_ERR51_enum;
            sw              = rw;
            hw              = r;
            spec_access     = rw;
            reset           = 0x1;
            reset_mask      = 0x1;
            spec_sw_default = 0x0;
            sw_default_mask = 0x0;
        } ERR51[19:19];
        ERR51->desc="
////1'b1 -> Enable  Latent Error Reporting for ECC SEC Error from on-chip SRAM/Fifo from <NV_DLA>.<SDP>.<N2>
////1'b0 -> Disable Latent Error Reporting for ECC SEC Error from on-chip SRAM/Fifo from <NV_DLA>.<SDP>.<N2>
";
        enum ERRSLICE1_LATENTERR_ENABLE_ERR50_enum {
            DISABLE = 1'd0;
            ENABLE = 1'd1;
        };
        field {
            encode          = ERRSLICE1_LATENTERR_ENABLE_ERR50_enum;
            sw              = rw;
            hw              = r;
            spec_access     = rw;
            reset           = 0x1;
            reset_mask      = 0x1;
            spec_sw_default = 0x0;
            sw_default_mask = 0x0;
        } ERR50[18:18];
        ERR50->desc="
////1'b1 -> Enable  Latent Error Reporting for ECC DED Error from on-chip SRAM/Fifo from <NV_DLA>.<SDP>.<B2>
////1'b0 -> Disable Latent Error Reporting for ECC DED Error from on-chip SRAM/Fifo from <NV_DLA>.<SDP>.<B2>
";
        enum ERRSLICE1_LATENTERR_ENABLE_ERR49_enum {
            DISABLE = 1'd0;
            ENABLE = 1'd1;
        };
        field {
            encode          = ERRSLICE1_LATENTERR_ENABLE_ERR49_enum;
            sw              = rw;
            hw              = r;
            spec_access     = rw;
            reset           = 0x1;
            reset_mask      = 0x1;
            spec_sw_default = 0x0;
            sw_default_mask = 0x0;
        } ERR49[17:17];
        ERR49->desc="
////1'b1 -> Enable  Latent Error Reporting for ECC SEC Error from on-chip SRAM/Fifo from <NV_DLA>.<SDP>.<B2>
////1'b0 -> Disable Latent Error Reporting for ECC SEC Error from on-chip SRAM/Fifo from <NV_DLA>.<SDP>.<B2>
";
        enum ERRSLICE1_LATENTERR_ENABLE_ERR48_enum {
            DISABLE = 1'd0;
            ENABLE = 1'd1;
        };
        field {
            encode          = ERRSLICE1_LATENTERR_ENABLE_ERR48_enum;
            sw              = rw;
            hw              = r;
            spec_access     = rw;
            reset           = 0x1;
            reset_mask      = 0x1;
            spec_sw_default = 0x0;
            sw_default_mask = 0x0;
        } ERR48[16:16];
        ERR48->desc="
////1'b1 -> Enable  Latent Error Reporting for ECC DED Error from on-chip SRAM/Fifo from <NV_DLA>.<SDP>
////1'b0 -> Disable Latent Error Reporting for ECC DED Error from on-chip SRAM/Fifo from <NV_DLA>.<SDP>
";
        enum ERRSLICE1_LATENTERR_ENABLE_ERR47_enum {
            DISABLE = 1'd0;
            ENABLE = 1'd1;
        };
        field {
            encode          = ERRSLICE1_LATENTERR_ENABLE_ERR47_enum;
            sw              = rw;
            hw              = r;
            spec_access     = rw;
            reset           = 0x1;
            reset_mask      = 0x1;
            spec_sw_default = 0x0;
            sw_default_mask = 0x0;
        } ERR47[15:15];
        ERR47->desc="
////1'b1 -> Enable  Latent Error Reporting for ECC SEC Error from on-chip SRAM/Fifo from <NV_DLA>.<SDP>
////1'b0 -> Disable Latent Error Reporting for ECC SEC Error from on-chip SRAM/Fifo from <NV_DLA>.<SDP>
";
        enum ERRSLICE1_LATENTERR_ENABLE_ERR46_enum {
            DISABLE = 1'd0;
            ENABLE = 1'd1;
        };
        field {
            encode          = ERRSLICE1_LATENTERR_ENABLE_ERR46_enum;
            sw              = rw;
            hw              = r;
            spec_access     = rw;
            reset           = 0x1;
            reset_mask      = 0x1;
            spec_sw_default = 0x0;
            sw_default_mask = 0x0;
        } ERR46[14:14];
        ERR46->desc="
////1'b1 -> Enable  Latent Error Reporting for ECC DED Error from on-chip SRAM/Fifo from <NV_DLA>.<CACC>.<D7BUF>
////1'b0 -> Disable Latent Error Reporting for ECC DED Error from on-chip SRAM/Fifo from <NV_DLA>.<CACC>.<D7BUF>
";
        enum ERRSLICE1_LATENTERR_ENABLE_ERR45_enum {
            DISABLE = 1'd0;
            ENABLE = 1'd1;
        };
        field {
            encode          = ERRSLICE1_LATENTERR_ENABLE_ERR45_enum;
            sw              = rw;
            hw              = r;
            spec_access     = rw;
            reset           = 0x1;
            reset_mask      = 0x1;
            spec_sw_default = 0x0;
            sw_default_mask = 0x0;
        } ERR45[13:13];
        ERR45->desc="
////1'b1 -> Enable  Latent Error Reporting for ECC SEC Error from on-chip SRAM/Fifo from <NV_DLA>.<CACC>.<D7BUF>
////1'b0 -> Disable Latent Error Reporting for ECC SEC Error from on-chip SRAM/Fifo from <NV_DLA>.<CACC>.<D7BUF>
";
        enum ERRSLICE1_LATENTERR_ENABLE_ERR44_enum {
            DISABLE = 1'd0;
            ENABLE = 1'd1;
        };
        field {
            encode          = ERRSLICE1_LATENTERR_ENABLE_ERR44_enum;
            sw              = rw;
            hw              = r;
            spec_access     = rw;
            reset           = 0x1;
            reset_mask      = 0x1;
            spec_sw_default = 0x0;
            sw_default_mask = 0x0;
        } ERR44[12:12];
        ERR44->desc="
////1'b1 -> Enable  Latent Error Reporting for ECC DED Error from on-chip SRAM/Fifo from <NV_DLA>.<CACC>.<D6BUF>
////1'b0 -> Disable Latent Error Reporting for ECC DED Error from on-chip SRAM/Fifo from <NV_DLA>.<CACC>.<D6BUF>
";
        enum ERRSLICE1_LATENTERR_ENABLE_ERR43_enum {
            DISABLE = 1'd0;
            ENABLE = 1'd1;
        };
        field {
            encode          = ERRSLICE1_LATENTERR_ENABLE_ERR43_enum;
            sw              = rw;
            hw              = r;
            spec_access     = rw;
            reset           = 0x1;
            reset_mask      = 0x1;
            spec_sw_default = 0x0;
            sw_default_mask = 0x0;
        } ERR43[11:11];
        ERR43->desc="
////1'b1 -> Enable  Latent Error Reporting for ECC SEC Error from on-chip SRAM/Fifo from <NV_DLA>.<CACC>.<D6BUF>
////1'b0 -> Disable Latent Error Reporting for ECC SEC Error from on-chip SRAM/Fifo from <NV_DLA>.<CACC>.<D6BUF>
";
        enum ERRSLICE1_LATENTERR_ENABLE_ERR42_enum {
            DISABLE = 1'd0;
            ENABLE = 1'd1;
        };
        field {
            encode          = ERRSLICE1_LATENTERR_ENABLE_ERR42_enum;
            sw              = rw;
            hw              = r;
            spec_access     = rw;
            reset           = 0x1;
            reset_mask      = 0x1;
            spec_sw_default = 0x0;
            sw_default_mask = 0x0;
        } ERR42[10:10];
        ERR42->desc="
////1'b1 -> Enable  Latent Error Reporting for ECC DED Error from on-chip SRAM/Fifo from <NV_DLA>.<CACC>.<D5BUF>
////1'b0 -> Disable Latent Error Reporting for ECC DED Error from on-chip SRAM/Fifo from <NV_DLA>.<CACC>.<D5BUF>
";
        enum ERRSLICE1_LATENTERR_ENABLE_ERR41_enum {
            DISABLE = 1'd0;
            ENABLE = 1'd1;
        };
        field {
            encode          = ERRSLICE1_LATENTERR_ENABLE_ERR41_enum;
            sw              = rw;
            hw              = r;
            spec_access     = rw;
            reset           = 0x1;
            reset_mask      = 0x1;
            spec_sw_default = 0x0;
            sw_default_mask = 0x0;
        } ERR41[9:9];
        ERR41->desc="
////1'b1 -> Enable  Latent Error Reporting for ECC SEC Error from on-chip SRAM/Fifo from <NV_DLA>.<CACC>.<D5BUF>
////1'b0 -> Disable Latent Error Reporting for ECC SEC Error from on-chip SRAM/Fifo from <NV_DLA>.<CACC>.<D5BUF>
";
        enum ERRSLICE1_LATENTERR_ENABLE_ERR40_enum {
            DISABLE = 1'd0;
            ENABLE = 1'd1;
        };
        field {
            encode          = ERRSLICE1_LATENTERR_ENABLE_ERR40_enum;
            sw              = rw;
            hw              = r;
            spec_access     = rw;
            reset           = 0x1;
            reset_mask      = 0x1;
            spec_sw_default = 0x0;
            sw_default_mask = 0x0;
        } ERR40[8:8];
        ERR40->desc="
////1'b1 -> Enable  Latent Error Reporting for ECC DED Error from on-chip SRAM/Fifo from <NV_DLA>.<CACC>.<D4BUF>
////1'b0 -> Disable Latent Error Reporting for ECC DED Error from on-chip SRAM/Fifo from <NV_DLA>.<CACC>.<D4BUF>
";
        enum ERRSLICE1_LATENTERR_ENABLE_ERR39_enum {
            DISABLE = 1'd0;
            ENABLE = 1'd1;
        };
        field {
            encode          = ERRSLICE1_LATENTERR_ENABLE_ERR39_enum;
            sw              = rw;
            hw              = r;
            spec_access     = rw;
            reset           = 0x1;
            reset_mask      = 0x1;
            spec_sw_default = 0x0;
            sw_default_mask = 0x0;
        } ERR39[7:7];
        ERR39->desc="
////1'b1 -> Enable  Latent Error Reporting for ECC SEC Error from on-chip SRAM/Fifo from <NV_DLA>.<CACC>.<D4BUF>
////1'b0 -> Disable Latent Error Reporting for ECC SEC Error from on-chip SRAM/Fifo from <NV_DLA>.<CACC>.<D4BUF>
";
        enum ERRSLICE1_LATENTERR_ENABLE_ERR38_enum {
            DISABLE = 1'd0;
            ENABLE = 1'd1;
        };
        field {
            encode          = ERRSLICE1_LATENTERR_ENABLE_ERR38_enum;
            sw              = rw;
            hw              = r;
            spec_access     = rw;
            reset           = 0x1;
            reset_mask      = 0x1;
            spec_sw_default = 0x0;
            sw_default_mask = 0x0;
        } ERR38[6:6];
        ERR38->desc="
////1'b1 -> Enable  Latent Error Reporting for ECC DED Error from on-chip SRAM/Fifo from <NV_DLA>.<CACC>.<D3BUF>
////1'b0 -> Disable Latent Error Reporting for ECC DED Error from on-chip SRAM/Fifo from <NV_DLA>.<CACC>.<D3BUF>
";
        enum ERRSLICE1_LATENTERR_ENABLE_ERR37_enum {
            DISABLE = 1'd0;
            ENABLE = 1'd1;
        };
        field {
            encode          = ERRSLICE1_LATENTERR_ENABLE_ERR37_enum;
            sw              = rw;
            hw              = r;
            spec_access     = rw;
            reset           = 0x1;
            reset_mask      = 0x1;
            spec_sw_default = 0x0;
            sw_default_mask = 0x0;
        } ERR37[5:5];
        ERR37->desc="
////1'b1 -> Enable  Latent Error Reporting for ECC SEC Error from on-chip SRAM/Fifo from <NV_DLA>.<CACC>.<D3BUF>
////1'b0 -> Disable Latent Error Reporting for ECC SEC Error from on-chip SRAM/Fifo from <NV_DLA>.<CACC>.<D3BUF>
";
        enum ERRSLICE1_LATENTERR_ENABLE_ERR36_enum {
            DISABLE = 1'd0;
            ENABLE = 1'd1;
        };
        field {
            encode          = ERRSLICE1_LATENTERR_ENABLE_ERR36_enum;
            sw              = rw;
            hw              = r;
            spec_access     = rw;
            reset           = 0x1;
            reset_mask      = 0x1;
            spec_sw_default = 0x0;
            sw_default_mask = 0x0;
        } ERR36[4:4];
        ERR36->desc="
////1'b1 -> Enable  Latent Error Reporting for ECC DED Error from on-chip SRAM/Fifo from <NV_DLA>.<CACC>.<D2BUF>
////1'b0 -> Disable Latent Error Reporting for ECC DED Error from on-chip SRAM/Fifo from <NV_DLA>.<CACC>.<D2BUF>
";
        enum ERRSLICE1_LATENTERR_ENABLE_ERR35_enum {
            DISABLE = 1'd0;
            ENABLE = 1'd1;
        };
        field {
            encode          = ERRSLICE1_LATENTERR_ENABLE_ERR35_enum;
            sw              = rw;
            hw              = r;
            spec_access     = rw;
            reset           = 0x1;
            reset_mask      = 0x1;
            spec_sw_default = 0x0;
            sw_default_mask = 0x0;
        } ERR35[3:3];
        ERR35->desc="
////1'b1 -> Enable  Latent Error Reporting for ECC SEC Error from on-chip SRAM/Fifo from <NV_DLA>.<CACC>.<D2BUF>
////1'b0 -> Disable Latent Error Reporting for ECC SEC Error from on-chip SRAM/Fifo from <NV_DLA>.<CACC>.<D2BUF>
";
        enum ERRSLICE1_LATENTERR_ENABLE_ERR34_enum {
            DISABLE = 1'd0;
            ENABLE = 1'd1;
        };
        field {
            encode          = ERRSLICE1_LATENTERR_ENABLE_ERR34_enum;
            sw              = rw;
            hw              = r;
            spec_access     = rw;
            reset           = 0x1;
            reset_mask      = 0x1;
            spec_sw_default = 0x0;
            sw_default_mask = 0x0;
        } ERR34[2:2];
        ERR34->desc="
////1'b1 -> Enable  Latent Error Reporting for ECC DED Error from on-chip SRAM/Fifo from <NV_DLA>.<CACC>.<D1BUF>
////1'b0 -> Disable Latent Error Reporting for ECC DED Error from on-chip SRAM/Fifo from <NV_DLA>.<CACC>.<D1BUF>
";
        enum ERRSLICE1_LATENTERR_ENABLE_ERR33_enum {
            DISABLE = 1'd0;
            ENABLE = 1'd1;
        };
        field {
            encode          = ERRSLICE1_LATENTERR_ENABLE_ERR33_enum;
            sw              = rw;
            hw              = r;
            spec_access     = rw;
            reset           = 0x1;
            reset_mask      = 0x1;
            spec_sw_default = 0x0;
            sw_default_mask = 0x0;
        } ERR33[1:1];
        ERR33->desc="
////1'b1 -> Enable  Latent Error Reporting for ECC SEC Error from on-chip SRAM/Fifo from <NV_DLA>.<CACC>.<D1BUF>
////1'b0 -> Disable Latent Error Reporting for ECC SEC Error from on-chip SRAM/Fifo from <NV_DLA>.<CACC>.<D1BUF>
";
        enum ERRSLICE1_LATENTERR_ENABLE_ERR32_enum {
            DISABLE = 1'd0;
            ENABLE = 1'd1;
        };
        field {
            encode          = ERRSLICE1_LATENTERR_ENABLE_ERR32_enum;
            sw              = rw;
            hw              = r;
            spec_access     = rw;
            reset           = 0x1;
            reset_mask      = 0x1;
            spec_sw_default = 0x0;
            sw_default_mask = 0x0;
        } ERR32[0:0];
        ERR32->desc="
////1'b1 -> Enable  Latent Error Reporting for ECC DED Error from on-chip SRAM/Fifo from <NV_DLA>.<CACC>.<D0BUF>
////1'b0 -> Disable Latent Error Reporting for ECC DED Error from on-chip SRAM/Fifo from <NV_DLA>.<CACC>.<D0BUF>
";
    }ERRSLICE1_LATENTERR_ENABLE @0x70;
    reg {
        name = "ERRSLICE1_LATENTERR_FORCE";
        enum ERRSLICE1_LATENTERR_FORCE_ERR63_enum {
            NOFORCE = 1'd0;
            FORCE = 1'd1;
        };
        field {
            encode          = ERRSLICE1_LATENTERR_FORCE_ERR63_enum;
            sw              = w;
            hw              = r;
            spec_access     = w;
            reset           = 0x0;
            reset_mask      = 0x1;
            spec_sw_default = 0x0;
            sw_default_mask = 0x0;
        } ERR63[31:31];
        ERR63->desc="
////1'b1 -> Force Assertion of Latent Error Reporting for ECC SEC Error from on-chip SRAM/Fifo from <NV_DLA>.<FALCON>.<IMEM>
////1'b0 -> Do Nothing
";
        enum ERRSLICE1_LATENTERR_FORCE_ERR62_enum {
            NOFORCE = 1'd0;
            FORCE = 1'd1;
        };
        field {
            encode          = ERRSLICE1_LATENTERR_FORCE_ERR62_enum;
            sw              = w;
            hw              = r;
            spec_access     = w;
            reset           = 0x0;
            reset_mask      = 0x1;
            spec_sw_default = 0x0;
            sw_default_mask = 0x0;
        } ERR62[30:30];
        ERR62->desc="
////1'b1 -> Force Assertion of Latent Error Reporting for ECC DED Error from on-chip SRAM/Fifo from <NV_DLA>.<RUBIK>.<FIFO_B>
////1'b0 -> Do Nothing
";
        enum ERRSLICE1_LATENTERR_FORCE_ERR61_enum {
            NOFORCE = 1'd0;
            FORCE = 1'd1;
        };
        field {
            encode          = ERRSLICE1_LATENTERR_FORCE_ERR61_enum;
            sw              = w;
            hw              = r;
            spec_access     = w;
            reset           = 0x0;
            reset_mask      = 0x1;
            spec_sw_default = 0x0;
            sw_default_mask = 0x0;
        } ERR61[29:29];
        ERR61->desc="
////1'b1 -> Force Assertion of Latent Error Reporting for ECC SEC Error from on-chip SRAM/Fifo from <NV_DLA>.<RUBIK>.<FIFO_B>
////1'b0 -> Do Nothing
";
        enum ERRSLICE1_LATENTERR_FORCE_ERR60_enum {
            NOFORCE = 1'd0;
            FORCE = 1'd1;
        };
        field {
            encode          = ERRSLICE1_LATENTERR_FORCE_ERR60_enum;
            sw              = w;
            hw              = r;
            spec_access     = w;
            reset           = 0x0;
            reset_mask      = 0x1;
            spec_sw_default = 0x0;
            sw_default_mask = 0x0;
        } ERR60[28:28];
        ERR60->desc="
////1'b1 -> Force Assertion of Latent Error Reporting for ECC DED Error from on-chip SRAM/Fifo from <NV_DLA>.<RUBIK>.<FIFO_A>
////1'b0 -> Do Nothing
";
        enum ERRSLICE1_LATENTERR_FORCE_ERR59_enum {
            NOFORCE = 1'd0;
            FORCE = 1'd1;
        };
        field {
            encode          = ERRSLICE1_LATENTERR_FORCE_ERR59_enum;
            sw              = w;
            hw              = r;
            spec_access     = w;
            reset           = 0x0;
            reset_mask      = 0x1;
            spec_sw_default = 0x0;
            sw_default_mask = 0x0;
        } ERR59[27:27];
        ERR59->desc="
////1'b1 -> Force Assertion of Latent Error Reporting for ECC SEC Error from on-chip SRAM/Fifo from <NV_DLA>.<RUBIK>.<FIFO_A>
////1'b0 -> Do Nothing
";
        enum ERRSLICE1_LATENTERR_FORCE_ERR58_enum {
            NOFORCE = 1'd0;
            FORCE = 1'd1;
        };
        field {
            encode          = ERRSLICE1_LATENTERR_FORCE_ERR58_enum;
            sw              = w;
            hw              = r;
            spec_access     = w;
            reset           = 0x0;
            reset_mask      = 0x1;
            spec_sw_default = 0x0;
            sw_default_mask = 0x0;
        } ERR58[26:26];
        ERR58->desc="
////1'b1 -> Force Assertion of Latent Error Reporting for ECC DED Error from on-chip SRAM/Fifo from <NV_DLA>.<CDP>
////1'b0 -> Do Nothing
";
        enum ERRSLICE1_LATENTERR_FORCE_ERR57_enum {
            NOFORCE = 1'd0;
            FORCE = 1'd1;
        };
        field {
            encode          = ERRSLICE1_LATENTERR_FORCE_ERR57_enum;
            sw              = w;
            hw              = r;
            spec_access     = w;
            reset           = 0x0;
            reset_mask      = 0x1;
            spec_sw_default = 0x0;
            sw_default_mask = 0x0;
        } ERR57[25:25];
        ERR57->desc="
////1'b1 -> Force Assertion of Latent Error Reporting for ECC SEC Error from on-chip SRAM/Fifo from <NV_DLA>.<CDP>
////1'b0 -> Do Nothing
";
        enum ERRSLICE1_LATENTERR_FORCE_ERR56_enum {
            NOFORCE = 1'd0;
            FORCE = 1'd1;
        };
        field {
            encode          = ERRSLICE1_LATENTERR_FORCE_ERR56_enum;
            sw              = w;
            hw              = r;
            spec_access     = w;
            reset           = 0x0;
            reset_mask      = 0x1;
            spec_sw_default = 0x0;
            sw_default_mask = 0x0;
        } ERR56[24:24];
        ERR56->desc="
////1'b1 -> Force Assertion of Latent Error Reporting for ECC DED Error from on-chip SRAM/Fifo from <NV_DLA>.<PDP>
////1'b0 -> Do Nothing
";
        enum ERRSLICE1_LATENTERR_FORCE_ERR55_enum {
            NOFORCE = 1'd0;
            FORCE = 1'd1;
        };
        field {
            encode          = ERRSLICE1_LATENTERR_FORCE_ERR55_enum;
            sw              = w;
            hw              = r;
            spec_access     = w;
            reset           = 0x0;
            reset_mask      = 0x1;
            spec_sw_default = 0x0;
            sw_default_mask = 0x0;
        } ERR55[23:23];
        ERR55->desc="
////1'b1 -> Force Assertion of Latent Error Reporting for ECC SEC Error from on-chip SRAM/Fifo from <NV_DLA>.<PDP>
////1'b0 -> Do Nothing
";
        enum ERRSLICE1_LATENTERR_FORCE_ERR54_enum {
            NOFORCE = 1'd0;
            FORCE = 1'd1;
        };
        field {
            encode          = ERRSLICE1_LATENTERR_FORCE_ERR54_enum;
            sw              = w;
            hw              = r;
            spec_access     = w;
            reset           = 0x0;
            reset_mask      = 0x1;
            spec_sw_default = 0x0;
            sw_default_mask = 0x0;
        } ERR54[22:22];
        ERR54->desc="
////1'b1 -> Force Assertion of Latent Error Reporting for ECC DED Error from on-chip SRAM/Fifo from <NV_DLA>.<SDP>.<E2>
////1'b0 -> Do Nothing
";
        enum ERRSLICE1_LATENTERR_FORCE_ERR53_enum {
            NOFORCE = 1'd0;
            FORCE = 1'd1;
        };
        field {
            encode          = ERRSLICE1_LATENTERR_FORCE_ERR53_enum;
            sw              = w;
            hw              = r;
            spec_access     = w;
            reset           = 0x0;
            reset_mask      = 0x1;
            spec_sw_default = 0x0;
            sw_default_mask = 0x0;
        } ERR53[21:21];
        ERR53->desc="
////1'b1 -> Force Assertion of Latent Error Reporting for ECC SEC Error from on-chip SRAM/Fifo from <NV_DLA>.<SDP>.<E2>
////1'b0 -> Do Nothing
";
        enum ERRSLICE1_LATENTERR_FORCE_ERR52_enum {
            NOFORCE = 1'd0;
            FORCE = 1'd1;
        };
        field {
            encode          = ERRSLICE1_LATENTERR_FORCE_ERR52_enum;
            sw              = w;
            hw              = r;
            spec_access     = w;
            reset           = 0x0;
            reset_mask      = 0x1;
            spec_sw_default = 0x0;
            sw_default_mask = 0x0;
        } ERR52[20:20];
        ERR52->desc="
////1'b1 -> Force Assertion of Latent Error Reporting for ECC DED Error from on-chip SRAM/Fifo from <NV_DLA>.<SDP>.<N2>
////1'b0 -> Do Nothing
";
        enum ERRSLICE1_LATENTERR_FORCE_ERR51_enum {
            NOFORCE = 1'd0;
            FORCE = 1'd1;
        };
        field {
            encode          = ERRSLICE1_LATENTERR_FORCE_ERR51_enum;
            sw              = w;
            hw              = r;
            spec_access     = w;
            reset           = 0x0;
            reset_mask      = 0x1;
            spec_sw_default = 0x0;
            sw_default_mask = 0x0;
        } ERR51[19:19];
        ERR51->desc="
////1'b1 -> Force Assertion of Latent Error Reporting for ECC SEC Error from on-chip SRAM/Fifo from <NV_DLA>.<SDP>.<N2>
////1'b0 -> Do Nothing
";
        enum ERRSLICE1_LATENTERR_FORCE_ERR50_enum {
            NOFORCE = 1'd0;
            FORCE = 1'd1;
        };
        field {
            encode          = ERRSLICE1_LATENTERR_FORCE_ERR50_enum;
            sw              = w;
            hw              = r;
            spec_access     = w;
            reset           = 0x0;
            reset_mask      = 0x1;
            spec_sw_default = 0x0;
            sw_default_mask = 0x0;
        } ERR50[18:18];
        ERR50->desc="
////1'b1 -> Force Assertion of Latent Error Reporting for ECC DED Error from on-chip SRAM/Fifo from <NV_DLA>.<SDP>.<B2>
////1'b0 -> Do Nothing
";
        enum ERRSLICE1_LATENTERR_FORCE_ERR49_enum {
            NOFORCE = 1'd0;
            FORCE = 1'd1;
        };
        field {
            encode          = ERRSLICE1_LATENTERR_FORCE_ERR49_enum;
            sw              = w;
            hw              = r;
            spec_access     = w;
            reset           = 0x0;
            reset_mask      = 0x1;
            spec_sw_default = 0x0;
            sw_default_mask = 0x0;
        } ERR49[17:17];
        ERR49->desc="
////1'b1 -> Force Assertion of Latent Error Reporting for ECC SEC Error from on-chip SRAM/Fifo from <NV_DLA>.<SDP>.<B2>
////1'b0 -> Do Nothing
";
        enum ERRSLICE1_LATENTERR_FORCE_ERR48_enum {
            NOFORCE = 1'd0;
            FORCE = 1'd1;
        };
        field {
            encode          = ERRSLICE1_LATENTERR_FORCE_ERR48_enum;
            sw              = w;
            hw              = r;
            spec_access     = w;
            reset           = 0x0;
            reset_mask      = 0x1;
            spec_sw_default = 0x0;
            sw_default_mask = 0x0;
        } ERR48[16:16];
        ERR48->desc="
////1'b1 -> Force Assertion of Latent Error Reporting for ECC DED Error from on-chip SRAM/Fifo from <NV_DLA>.<SDP>
////1'b0 -> Do Nothing
";
        enum ERRSLICE1_LATENTERR_FORCE_ERR47_enum {
            NOFORCE = 1'd0;
            FORCE = 1'd1;
        };
        field {
            encode          = ERRSLICE1_LATENTERR_FORCE_ERR47_enum;
            sw              = w;
            hw              = r;
            spec_access     = w;
            reset           = 0x0;
            reset_mask      = 0x1;
            spec_sw_default = 0x0;
            sw_default_mask = 0x0;
        } ERR47[15:15];
        ERR47->desc="
////1'b1 -> Force Assertion of Latent Error Reporting for ECC SEC Error from on-chip SRAM/Fifo from <NV_DLA>.<SDP>
////1'b0 -> Do Nothing
";
        enum ERRSLICE1_LATENTERR_FORCE_ERR46_enum {
            NOFORCE = 1'd0;
            FORCE = 1'd1;
        };
        field {
            encode          = ERRSLICE1_LATENTERR_FORCE_ERR46_enum;
            sw              = w;
            hw              = r;
            spec_access     = w;
            reset           = 0x0;
            reset_mask      = 0x1;
            spec_sw_default = 0x0;
            sw_default_mask = 0x0;
        } ERR46[14:14];
        ERR46->desc="
////1'b1 -> Force Assertion of Latent Error Reporting for ECC DED Error from on-chip SRAM/Fifo from <NV_DLA>.<CACC>.<D7BUF>
////1'b0 -> Do Nothing
";
        enum ERRSLICE1_LATENTERR_FORCE_ERR45_enum {
            NOFORCE = 1'd0;
            FORCE = 1'd1;
        };
        field {
            encode          = ERRSLICE1_LATENTERR_FORCE_ERR45_enum;
            sw              = w;
            hw              = r;
            spec_access     = w;
            reset           = 0x0;
            reset_mask      = 0x1;
            spec_sw_default = 0x0;
            sw_default_mask = 0x0;
        } ERR45[13:13];
        ERR45->desc="
////1'b1 -> Force Assertion of Latent Error Reporting for ECC SEC Error from on-chip SRAM/Fifo from <NV_DLA>.<CACC>.<D7BUF>
////1'b0 -> Do Nothing
";
        enum ERRSLICE1_LATENTERR_FORCE_ERR44_enum {
            NOFORCE = 1'd0;
            FORCE = 1'd1;
        };
        field {
            encode          = ERRSLICE1_LATENTERR_FORCE_ERR44_enum;
            sw              = w;
            hw              = r;
            spec_access     = w;
            reset           = 0x0;
            reset_mask      = 0x1;
            spec_sw_default = 0x0;
            sw_default_mask = 0x0;
        } ERR44[12:12];
        ERR44->desc="
////1'b1 -> Force Assertion of Latent Error Reporting for ECC DED Error from on-chip SRAM/Fifo from <NV_DLA>.<CACC>.<D6BUF>
////1'b0 -> Do Nothing
";
        enum ERRSLICE1_LATENTERR_FORCE_ERR43_enum {
            NOFORCE = 1'd0;
            FORCE = 1'd1;
        };
        field {
            encode          = ERRSLICE1_LATENTERR_FORCE_ERR43_enum;
            sw              = w;
            hw              = r;
            spec_access     = w;
            reset           = 0x0;
            reset_mask      = 0x1;
            spec_sw_default = 0x0;
            sw_default_mask = 0x0;
        } ERR43[11:11];
        ERR43->desc="
////1'b1 -> Force Assertion of Latent Error Reporting for ECC SEC Error from on-chip SRAM/Fifo from <NV_DLA>.<CACC>.<D6BUF>
////1'b0 -> Do Nothing
";
        enum ERRSLICE1_LATENTERR_FORCE_ERR42_enum {
            NOFORCE = 1'd0;
            FORCE = 1'd1;
        };
        field {
            encode          = ERRSLICE1_LATENTERR_FORCE_ERR42_enum;
            sw              = w;
            hw              = r;
            spec_access     = w;
            reset           = 0x0;
            reset_mask      = 0x1;
            spec_sw_default = 0x0;
            sw_default_mask = 0x0;
        } ERR42[10:10];
        ERR42->desc="
////1'b1 -> Force Assertion of Latent Error Reporting for ECC DED Error from on-chip SRAM/Fifo from <NV_DLA>.<CACC>.<D5BUF>
////1'b0 -> Do Nothing
";
        enum ERRSLICE1_LATENTERR_FORCE_ERR41_enum {
            NOFORCE = 1'd0;
            FORCE = 1'd1;
        };
        field {
            encode          = ERRSLICE1_LATENTERR_FORCE_ERR41_enum;
            sw              = w;
            hw              = r;
            spec_access     = w;
            reset           = 0x0;
            reset_mask      = 0x1;
            spec_sw_default = 0x0;
            sw_default_mask = 0x0;
        } ERR41[9:9];
        ERR41->desc="
////1'b1 -> Force Assertion of Latent Error Reporting for ECC SEC Error from on-chip SRAM/Fifo from <NV_DLA>.<CACC>.<D5BUF>
////1'b0 -> Do Nothing
";
        enum ERRSLICE1_LATENTERR_FORCE_ERR40_enum {
            NOFORCE = 1'd0;
            FORCE = 1'd1;
        };
        field {
            encode          = ERRSLICE1_LATENTERR_FORCE_ERR40_enum;
            sw              = w;
            hw              = r;
            spec_access     = w;
            reset           = 0x0;
            reset_mask      = 0x1;
            spec_sw_default = 0x0;
            sw_default_mask = 0x0;
        } ERR40[8:8];
        ERR40->desc="
////1'b1 -> Force Assertion of Latent Error Reporting for ECC DED Error from on-chip SRAM/Fifo from <NV_DLA>.<CACC>.<D4BUF>
////1'b0 -> Do Nothing
";
        enum ERRSLICE1_LATENTERR_FORCE_ERR39_enum {
            NOFORCE = 1'd0;
            FORCE = 1'd1;
        };
        field {
            encode          = ERRSLICE1_LATENTERR_FORCE_ERR39_enum;
            sw              = w;
            hw              = r;
            spec_access     = w;
            reset           = 0x0;
            reset_mask      = 0x1;
            spec_sw_default = 0x0;
            sw_default_mask = 0x0;
        } ERR39[7:7];
        ERR39->desc="
////1'b1 -> Force Assertion of Latent Error Reporting for ECC SEC Error from on-chip SRAM/Fifo from <NV_DLA>.<CACC>.<D4BUF>
////1'b0 -> Do Nothing
";
        enum ERRSLICE1_LATENTERR_FORCE_ERR38_enum {
            NOFORCE = 1'd0;
            FORCE = 1'd1;
        };
        field {
            encode          = ERRSLICE1_LATENTERR_FORCE_ERR38_enum;
            sw              = w;
            hw              = r;
            spec_access     = w;
            reset           = 0x0;
            reset_mask      = 0x1;
            spec_sw_default = 0x0;
            sw_default_mask = 0x0;
        } ERR38[6:6];
        ERR38->desc="
////1'b1 -> Force Assertion of Latent Error Reporting for ECC DED Error from on-chip SRAM/Fifo from <NV_DLA>.<CACC>.<D3BUF>
////1'b0 -> Do Nothing
";
        enum ERRSLICE1_LATENTERR_FORCE_ERR37_enum {
            NOFORCE = 1'd0;
            FORCE = 1'd1;
        };
        field {
            encode          = ERRSLICE1_LATENTERR_FORCE_ERR37_enum;
            sw              = w;
            hw              = r;
            spec_access     = w;
            reset           = 0x0;
            reset_mask      = 0x1;
            spec_sw_default = 0x0;
            sw_default_mask = 0x0;
        } ERR37[5:5];
        ERR37->desc="
////1'b1 -> Force Assertion of Latent Error Reporting for ECC SEC Error from on-chip SRAM/Fifo from <NV_DLA>.<CACC>.<D3BUF>
////1'b0 -> Do Nothing
";
        enum ERRSLICE1_LATENTERR_FORCE_ERR36_enum {
            NOFORCE = 1'd0;
            FORCE = 1'd1;
        };
        field {
            encode          = ERRSLICE1_LATENTERR_FORCE_ERR36_enum;
            sw              = w;
            hw              = r;
            spec_access     = w;
            reset           = 0x0;
            reset_mask      = 0x1;
            spec_sw_default = 0x0;
            sw_default_mask = 0x0;
        } ERR36[4:4];
        ERR36->desc="
////1'b1 -> Force Assertion of Latent Error Reporting for ECC DED Error from on-chip SRAM/Fifo from <NV_DLA>.<CACC>.<D2BUF>
////1'b0 -> Do Nothing
";
        enum ERRSLICE1_LATENTERR_FORCE_ERR35_enum {
            NOFORCE = 1'd0;
            FORCE = 1'd1;
        };
        field {
            encode          = ERRSLICE1_LATENTERR_FORCE_ERR35_enum;
            sw              = w;
            hw              = r;
            spec_access     = w;
            reset           = 0x0;
            reset_mask      = 0x1;
            spec_sw_default = 0x0;
            sw_default_mask = 0x0;
        } ERR35[3:3];
        ERR35->desc="
////1'b1 -> Force Assertion of Latent Error Reporting for ECC SEC Error from on-chip SRAM/Fifo from <NV_DLA>.<CACC>.<D2BUF>
////1'b0 -> Do Nothing
";
        enum ERRSLICE1_LATENTERR_FORCE_ERR34_enum {
            NOFORCE = 1'd0;
            FORCE = 1'd1;
        };
        field {
            encode          = ERRSLICE1_LATENTERR_FORCE_ERR34_enum;
            sw              = w;
            hw              = r;
            spec_access     = w;
            reset           = 0x0;
            reset_mask      = 0x1;
            spec_sw_default = 0x0;
            sw_default_mask = 0x0;
        } ERR34[2:2];
        ERR34->desc="
////1'b1 -> Force Assertion of Latent Error Reporting for ECC DED Error from on-chip SRAM/Fifo from <NV_DLA>.<CACC>.<D1BUF>
////1'b0 -> Do Nothing
";
        enum ERRSLICE1_LATENTERR_FORCE_ERR33_enum {
            NOFORCE = 1'd0;
            FORCE = 1'd1;
        };
        field {
            encode          = ERRSLICE1_LATENTERR_FORCE_ERR33_enum;
            sw              = w;
            hw              = r;
            spec_access     = w;
            reset           = 0x0;
            reset_mask      = 0x1;
            spec_sw_default = 0x0;
            sw_default_mask = 0x0;
        } ERR33[1:1];
        ERR33->desc="
////1'b1 -> Force Assertion of Latent Error Reporting for ECC SEC Error from on-chip SRAM/Fifo from <NV_DLA>.<CACC>.<D1BUF>
////1'b0 -> Do Nothing
";
        enum ERRSLICE1_LATENTERR_FORCE_ERR32_enum {
            NOFORCE = 1'd0;
            FORCE = 1'd1;
        };
        field {
            encode          = ERRSLICE1_LATENTERR_FORCE_ERR32_enum;
            sw              = w;
            hw              = r;
            spec_access     = w;
            reset           = 0x0;
            reset_mask      = 0x1;
            spec_sw_default = 0x0;
            sw_default_mask = 0x0;
        } ERR32[0:0];
        ERR32->desc="
////1'b1 -> Force Assertion of Latent Error Reporting for ECC DED Error from on-chip SRAM/Fifo from <NV_DLA>.<CACC>.<D0BUF>
////1'b0 -> Do Nothing
";
    }ERRSLICE1_LATENTERR_FORCE @0x74;
    reg {
        name = "ERRSLICE1_LATENTERR_STATUS";
        desc = "
////SW must write 1 to clear the fields of this register.
////Bits in this register continue to be logged independent of the value of LatentError_Enable register, to avoid silent dropping of errors.
";
        field {
            sw              = rw;
            hw              = r;
            spec_access     = rw;
            reset           = 0x0;
            reset_mask      = 0x1;
            spec_sw_default = 0x0;
            sw_default_mask = 0x0;
        } ERR63[31:31];
        ERR63->desc="
////1'b1 -> Error_63_pulse[1:0] for ECC SEC Error from on-chip SRAM/Fifo from <NV_DLA>.<FALCON>.<IMEM> was equal to 2'b10.
////1'b0 -> Error_63_pulse[1:0] for ECC SEC Error from on-chip SRAM/Fifo from <NV_DLA>.<FALCON>.<IMEM> was equal to 2'b01.
";
        field {
            sw              = rw;
            hw              = r;
            spec_access     = rw;
            reset           = 0x0;
            reset_mask      = 0x1;
            spec_sw_default = 0x0;
            sw_default_mask = 0x0;
        } ERR62[30:30];
        ERR62->desc="
////1'b1 -> Error_62_pulse[1:0] for ECC DED Error from on-chip SRAM/Fifo from <NV_DLA>.<RUBIK>.<FIFO_B> was equal to 2'b10.
////1'b0 -> Error_62_pulse[1:0] for ECC DED Error from on-chip SRAM/Fifo from <NV_DLA>.<RUBIK>.<FIFO_B> was equal to 2'b01.
";
        field {
            sw              = rw;
            hw              = r;
            spec_access     = rw;
            reset           = 0x0;
            reset_mask      = 0x1;
            spec_sw_default = 0x0;
            sw_default_mask = 0x0;
        } ERR61[29:29];
        ERR61->desc="
////1'b1 -> Error_61_pulse[1:0] for ECC SEC Error from on-chip SRAM/Fifo from <NV_DLA>.<RUBIK>.<FIFO_B> was equal to 2'b10.
////1'b0 -> Error_61_pulse[1:0] for ECC SEC Error from on-chip SRAM/Fifo from <NV_DLA>.<RUBIK>.<FIFO_B> was equal to 2'b01.
";
        field {
            sw              = rw;
            hw              = r;
            spec_access     = rw;
            reset           = 0x0;
            reset_mask      = 0x1;
            spec_sw_default = 0x0;
            sw_default_mask = 0x0;
        } ERR60[28:28];
        ERR60->desc="
////1'b1 -> Error_60_pulse[1:0] for ECC DED Error from on-chip SRAM/Fifo from <NV_DLA>.<RUBIK>.<FIFO_A> was equal to 2'b10.
////1'b0 -> Error_60_pulse[1:0] for ECC DED Error from on-chip SRAM/Fifo from <NV_DLA>.<RUBIK>.<FIFO_A> was equal to 2'b01.
";
        field {
            sw              = rw;
            hw              = r;
            spec_access     = rw;
            reset           = 0x0;
            reset_mask      = 0x1;
            spec_sw_default = 0x0;
            sw_default_mask = 0x0;
        } ERR59[27:27];
        ERR59->desc="
////1'b1 -> Error_59_pulse[1:0] for ECC SEC Error from on-chip SRAM/Fifo from <NV_DLA>.<RUBIK>.<FIFO_A> was equal to 2'b10.
////1'b0 -> Error_59_pulse[1:0] for ECC SEC Error from on-chip SRAM/Fifo from <NV_DLA>.<RUBIK>.<FIFO_A> was equal to 2'b01.
";
        field {
            sw              = rw;
            hw              = r;
            spec_access     = rw;
            reset           = 0x0;
            reset_mask      = 0x1;
            spec_sw_default = 0x0;
            sw_default_mask = 0x0;
        } ERR58[26:26];
        ERR58->desc="
////1'b1 -> Error_58_pulse[1:0] for ECC DED Error from on-chip SRAM/Fifo from <NV_DLA>.<CDP> was equal to 2'b10.
////1'b0 -> Error_58_pulse[1:0] for ECC DED Error from on-chip SRAM/Fifo from <NV_DLA>.<CDP> was equal to 2'b01.
";
        field {
            sw              = rw;
            hw              = r;
            spec_access     = rw;
            reset           = 0x0;
            reset_mask      = 0x1;
            spec_sw_default = 0x0;
            sw_default_mask = 0x0;
        } ERR57[25:25];
        ERR57->desc="
////1'b1 -> Error_57_pulse[1:0] for ECC SEC Error from on-chip SRAM/Fifo from <NV_DLA>.<CDP> was equal to 2'b10.
////1'b0 -> Error_57_pulse[1:0] for ECC SEC Error from on-chip SRAM/Fifo from <NV_DLA>.<CDP> was equal to 2'b01.
";
        field {
            sw              = rw;
            hw              = r;
            spec_access     = rw;
            reset           = 0x0;
            reset_mask      = 0x1;
            spec_sw_default = 0x0;
            sw_default_mask = 0x0;
        } ERR56[24:24];
        ERR56->desc="
////1'b1 -> Error_56_pulse[1:0] for ECC DED Error from on-chip SRAM/Fifo from <NV_DLA>.<PDP> was equal to 2'b10.
////1'b0 -> Error_56_pulse[1:0] for ECC DED Error from on-chip SRAM/Fifo from <NV_DLA>.<PDP> was equal to 2'b01.
";
        field {
            sw              = rw;
            hw              = r;
            spec_access     = rw;
            reset           = 0x0;
            reset_mask      = 0x1;
            spec_sw_default = 0x0;
            sw_default_mask = 0x0;
        } ERR55[23:23];
        ERR55->desc="
////1'b1 -> Error_55_pulse[1:0] for ECC SEC Error from on-chip SRAM/Fifo from <NV_DLA>.<PDP> was equal to 2'b10.
////1'b0 -> Error_55_pulse[1:0] for ECC SEC Error from on-chip SRAM/Fifo from <NV_DLA>.<PDP> was equal to 2'b01.
";
        field {
            sw              = rw;
            hw              = r;
            spec_access     = rw;
            reset           = 0x0;
            reset_mask      = 0x1;
            spec_sw_default = 0x0;
            sw_default_mask = 0x0;
        } ERR54[22:22];
        ERR54->desc="
////1'b1 -> Error_54_pulse[1:0] for ECC DED Error from on-chip SRAM/Fifo from <NV_DLA>.<SDP>.<E2> was equal to 2'b10.
////1'b0 -> Error_54_pulse[1:0] for ECC DED Error from on-chip SRAM/Fifo from <NV_DLA>.<SDP>.<E2> was equal to 2'b01.
";
        field {
            sw              = rw;
            hw              = r;
            spec_access     = rw;
            reset           = 0x0;
            reset_mask      = 0x1;
            spec_sw_default = 0x0;
            sw_default_mask = 0x0;
        } ERR53[21:21];
        ERR53->desc="
////1'b1 -> Error_53_pulse[1:0] for ECC SEC Error from on-chip SRAM/Fifo from <NV_DLA>.<SDP>.<E2> was equal to 2'b10.
////1'b0 -> Error_53_pulse[1:0] for ECC SEC Error from on-chip SRAM/Fifo from <NV_DLA>.<SDP>.<E2> was equal to 2'b01.
";
        field {
            sw              = rw;
            hw              = r;
            spec_access     = rw;
            reset           = 0x0;
            reset_mask      = 0x1;
            spec_sw_default = 0x0;
            sw_default_mask = 0x0;
        } ERR52[20:20];
        ERR52->desc="
////1'b1 -> Error_52_pulse[1:0] for ECC DED Error from on-chip SRAM/Fifo from <NV_DLA>.<SDP>.<N2> was equal to 2'b10.
////1'b0 -> Error_52_pulse[1:0] for ECC DED Error from on-chip SRAM/Fifo from <NV_DLA>.<SDP>.<N2> was equal to 2'b01.
";
        field {
            sw              = rw;
            hw              = r;
            spec_access     = rw;
            reset           = 0x0;
            reset_mask      = 0x1;
            spec_sw_default = 0x0;
            sw_default_mask = 0x0;
        } ERR51[19:19];
        ERR51->desc="
////1'b1 -> Error_51_pulse[1:0] for ECC SEC Error from on-chip SRAM/Fifo from <NV_DLA>.<SDP>.<N2> was equal to 2'b10.
////1'b0 -> Error_51_pulse[1:0] for ECC SEC Error from on-chip SRAM/Fifo from <NV_DLA>.<SDP>.<N2> was equal to 2'b01.
";
        field {
            sw              = rw;
            hw              = r;
            spec_access     = rw;
            reset           = 0x0;
            reset_mask      = 0x1;
            spec_sw_default = 0x0;
            sw_default_mask = 0x0;
        } ERR50[18:18];
        ERR50->desc="
////1'b1 -> Error_50_pulse[1:0] for ECC DED Error from on-chip SRAM/Fifo from <NV_DLA>.<SDP>.<B2> was equal to 2'b10.
////1'b0 -> Error_50_pulse[1:0] for ECC DED Error from on-chip SRAM/Fifo from <NV_DLA>.<SDP>.<B2> was equal to 2'b01.
";
        field {
            sw              = rw;
            hw              = r;
            spec_access     = rw;
            reset           = 0x0;
            reset_mask      = 0x1;
            spec_sw_default = 0x0;
            sw_default_mask = 0x0;
        } ERR49[17:17];
        ERR49->desc="
////1'b1 -> Error_49_pulse[1:0] for ECC SEC Error from on-chip SRAM/Fifo from <NV_DLA>.<SDP>.<B2> was equal to 2'b10.
////1'b0 -> Error_49_pulse[1:0] for ECC SEC Error from on-chip SRAM/Fifo from <NV_DLA>.<SDP>.<B2> was equal to 2'b01.
";
        field {
            sw              = rw;
            hw              = r;
            spec_access     = rw;
            reset           = 0x0;
            reset_mask      = 0x1;
            spec_sw_default = 0x0;
            sw_default_mask = 0x0;
        } ERR48[16:16];
        ERR48->desc="
////1'b1 -> Error_48_pulse[1:0] for ECC DED Error from on-chip SRAM/Fifo from <NV_DLA>.<SDP> was equal to 2'b10.
////1'b0 -> Error_48_pulse[1:0] for ECC DED Error from on-chip SRAM/Fifo from <NV_DLA>.<SDP> was equal to 2'b01.
";
        field {
            sw              = rw;
            hw              = r;
            spec_access     = rw;
            reset           = 0x0;
            reset_mask      = 0x1;
            spec_sw_default = 0x0;
            sw_default_mask = 0x0;
        } ERR47[15:15];
        ERR47->desc="
////1'b1 -> Error_47_pulse[1:0] for ECC SEC Error from on-chip SRAM/Fifo from <NV_DLA>.<SDP> was equal to 2'b10.
////1'b0 -> Error_47_pulse[1:0] for ECC SEC Error from on-chip SRAM/Fifo from <NV_DLA>.<SDP> was equal to 2'b01.
";
        field {
            sw              = rw;
            hw              = r;
            spec_access     = rw;
            reset           = 0x0;
            reset_mask      = 0x1;
            spec_sw_default = 0x0;
            sw_default_mask = 0x0;
        } ERR46[14:14];
        ERR46->desc="
////1'b1 -> Error_46_pulse[1:0] for ECC DED Error from on-chip SRAM/Fifo from <NV_DLA>.<CACC>.<D7BUF> was equal to 2'b10.
////1'b0 -> Error_46_pulse[1:0] for ECC DED Error from on-chip SRAM/Fifo from <NV_DLA>.<CACC>.<D7BUF> was equal to 2'b01.
";
        field {
            sw              = rw;
            hw              = r;
            spec_access     = rw;
            reset           = 0x0;
            reset_mask      = 0x1;
            spec_sw_default = 0x0;
            sw_default_mask = 0x0;
        } ERR45[13:13];
        ERR45->desc="
////1'b1 -> Error_45_pulse[1:0] for ECC SEC Error from on-chip SRAM/Fifo from <NV_DLA>.<CACC>.<D7BUF> was equal to 2'b10.
////1'b0 -> Error_45_pulse[1:0] for ECC SEC Error from on-chip SRAM/Fifo from <NV_DLA>.<CACC>.<D7BUF> was equal to 2'b01.
";
        field {
            sw              = rw;
            hw              = r;
            spec_access     = rw;
            reset           = 0x0;
            reset_mask      = 0x1;
            spec_sw_default = 0x0;
            sw_default_mask = 0x0;
        } ERR44[12:12];
        ERR44->desc="
////1'b1 -> Error_44_pulse[1:0] for ECC DED Error from on-chip SRAM/Fifo from <NV_DLA>.<CACC>.<D6BUF> was equal to 2'b10.
////1'b0 -> Error_44_pulse[1:0] for ECC DED Error from on-chip SRAM/Fifo from <NV_DLA>.<CACC>.<D6BUF> was equal to 2'b01.
";
        field {
            sw              = rw;
            hw              = r;
            spec_access     = rw;
            reset           = 0x0;
            reset_mask      = 0x1;
            spec_sw_default = 0x0;
            sw_default_mask = 0x0;
        } ERR43[11:11];
        ERR43->desc="
////1'b1 -> Error_43_pulse[1:0] for ECC SEC Error from on-chip SRAM/Fifo from <NV_DLA>.<CACC>.<D6BUF> was equal to 2'b10.
////1'b0 -> Error_43_pulse[1:0] for ECC SEC Error from on-chip SRAM/Fifo from <NV_DLA>.<CACC>.<D6BUF> was equal to 2'b01.
";
        field {
            sw              = rw;
            hw              = r;
            spec_access     = rw;
            reset           = 0x0;
            reset_mask      = 0x1;
            spec_sw_default = 0x0;
            sw_default_mask = 0x0;
        } ERR42[10:10];
        ERR42->desc="
////1'b1 -> Error_42_pulse[1:0] for ECC DED Error from on-chip SRAM/Fifo from <NV_DLA>.<CACC>.<D5BUF> was equal to 2'b10.
////1'b0 -> Error_42_pulse[1:0] for ECC DED Error from on-chip SRAM/Fifo from <NV_DLA>.<CACC>.<D5BUF> was equal to 2'b01.
";
        field {
            sw              = rw;
            hw              = r;
            spec_access     = rw;
            reset           = 0x0;
            reset_mask      = 0x1;
            spec_sw_default = 0x0;
            sw_default_mask = 0x0;
        } ERR41[9:9];
        ERR41->desc="
////1'b1 -> Error_41_pulse[1:0] for ECC SEC Error from on-chip SRAM/Fifo from <NV_DLA>.<CACC>.<D5BUF> was equal to 2'b10.
////1'b0 -> Error_41_pulse[1:0] for ECC SEC Error from on-chip SRAM/Fifo from <NV_DLA>.<CACC>.<D5BUF> was equal to 2'b01.
";
        field {
            sw              = rw;
            hw              = r;
            spec_access     = rw;
            reset           = 0x0;
            reset_mask      = 0x1;
            spec_sw_default = 0x0;
            sw_default_mask = 0x0;
        } ERR40[8:8];
        ERR40->desc="
////1'b1 -> Error_40_pulse[1:0] for ECC DED Error from on-chip SRAM/Fifo from <NV_DLA>.<CACC>.<D4BUF> was equal to 2'b10.
////1'b0 -> Error_40_pulse[1:0] for ECC DED Error from on-chip SRAM/Fifo from <NV_DLA>.<CACC>.<D4BUF> was equal to 2'b01.
";
        field {
            sw              = rw;
            hw              = r;
            spec_access     = rw;
            reset           = 0x0;
            reset_mask      = 0x1;
            spec_sw_default = 0x0;
            sw_default_mask = 0x0;
        } ERR39[7:7];
        ERR39->desc="
////1'b1 -> Error_39_pulse[1:0] for ECC SEC Error from on-chip SRAM/Fifo from <NV_DLA>.<CACC>.<D4BUF> was equal to 2'b10.
////1'b0 -> Error_39_pulse[1:0] for ECC SEC Error from on-chip SRAM/Fifo from <NV_DLA>.<CACC>.<D4BUF> was equal to 2'b01.
";
        field {
            sw              = rw;
            hw              = r;
            spec_access     = rw;
            reset           = 0x0;
            reset_mask      = 0x1;
            spec_sw_default = 0x0;
            sw_default_mask = 0x0;
        } ERR38[6:6];
        ERR38->desc="
////1'b1 -> Error_38_pulse[1:0] for ECC DED Error from on-chip SRAM/Fifo from <NV_DLA>.<CACC>.<D3BUF> was equal to 2'b10.
////1'b0 -> Error_38_pulse[1:0] for ECC DED Error from on-chip SRAM/Fifo from <NV_DLA>.<CACC>.<D3BUF> was equal to 2'b01.
";
        field {
            sw              = rw;
            hw              = r;
            spec_access     = rw;
            reset           = 0x0;
            reset_mask      = 0x1;
            spec_sw_default = 0x0;
            sw_default_mask = 0x0;
        } ERR37[5:5];
        ERR37->desc="
////1'b1 -> Error_37_pulse[1:0] for ECC SEC Error from on-chip SRAM/Fifo from <NV_DLA>.<CACC>.<D3BUF> was equal to 2'b10.
////1'b0 -> Error_37_pulse[1:0] for ECC SEC Error from on-chip SRAM/Fifo from <NV_DLA>.<CACC>.<D3BUF> was equal to 2'b01.
";
        field {
            sw              = rw;
            hw              = r;
            spec_access     = rw;
            reset           = 0x0;
            reset_mask      = 0x1;
            spec_sw_default = 0x0;
            sw_default_mask = 0x0;
        } ERR36[4:4];
        ERR36->desc="
////1'b1 -> Error_36_pulse[1:0] for ECC DED Error from on-chip SRAM/Fifo from <NV_DLA>.<CACC>.<D2BUF> was equal to 2'b10.
////1'b0 -> Error_36_pulse[1:0] for ECC DED Error from on-chip SRAM/Fifo from <NV_DLA>.<CACC>.<D2BUF> was equal to 2'b01.
";
        field {
            sw              = rw;
            hw              = r;
            spec_access     = rw;
            reset           = 0x0;
            reset_mask      = 0x1;
            spec_sw_default = 0x0;
            sw_default_mask = 0x0;
        } ERR35[3:3];
        ERR35->desc="
////1'b1 -> Error_35_pulse[1:0] for ECC SEC Error from on-chip SRAM/Fifo from <NV_DLA>.<CACC>.<D2BUF> was equal to 2'b10.
////1'b0 -> Error_35_pulse[1:0] for ECC SEC Error from on-chip SRAM/Fifo from <NV_DLA>.<CACC>.<D2BUF> was equal to 2'b01.
";
        field {
            sw              = rw;
            hw              = r;
            spec_access     = rw;
            reset           = 0x0;
            reset_mask      = 0x1;
            spec_sw_default = 0x0;
            sw_default_mask = 0x0;
        } ERR34[2:2];
        ERR34->desc="
////1'b1 -> Error_34_pulse[1:0] for ECC DED Error from on-chip SRAM/Fifo from <NV_DLA>.<CACC>.<D1BUF> was equal to 2'b10.
////1'b0 -> Error_34_pulse[1:0] for ECC DED Error from on-chip SRAM/Fifo from <NV_DLA>.<CACC>.<D1BUF> was equal to 2'b01.
";
        field {
            sw              = rw;
            hw              = r;
            spec_access     = rw;
            reset           = 0x0;
            reset_mask      = 0x1;
            spec_sw_default = 0x0;
            sw_default_mask = 0x0;
        } ERR33[1:1];
        ERR33->desc="
////1'b1 -> Error_33_pulse[1:0] for ECC SEC Error from on-chip SRAM/Fifo from <NV_DLA>.<CACC>.<D1BUF> was equal to 2'b10.
////1'b0 -> Error_33_pulse[1:0] for ECC SEC Error from on-chip SRAM/Fifo from <NV_DLA>.<CACC>.<D1BUF> was equal to 2'b01.
";
        field {
            sw              = rw;
            hw              = r;
            spec_access     = rw;
            reset           = 0x0;
            reset_mask      = 0x1;
            spec_sw_default = 0x0;
            sw_default_mask = 0x0;
        } ERR32[0:0];
        ERR32->desc="
////1'b1 -> Error_32_pulse[1:0] for ECC DED Error from on-chip SRAM/Fifo from <NV_DLA>.<CACC>.<D0BUF> was equal to 2'b10.
////1'b0 -> Error_32_pulse[1:0] for ECC DED Error from on-chip SRAM/Fifo from <NV_DLA>.<CACC>.<D0BUF> was equal to 2'b01.
";
    }ERRSLICE1_LATENTERR_STATUS @0x78;
    reg {
        name = "ERRSLICE1_COUNTER_RELOAD";
        enum ERRSLICE1_COUNTER_RELOAD_ERR63_enum {
            NORELOAD = 1'd0;
            RELOAD = 1'd1;
        };
        field {
            encode          = ERRSLICE1_COUNTER_RELOAD_ERR63_enum;
            sw              = w;
            hw              = r;
            spec_access     = w;
            reset           = 0x0;
            reset_mask      = 0x1;
            spec_sw_default = 0x0;
            sw_default_mask = 0x0;
        } ERR63[31:31];
        ERR63->desc="
////1'b1 -> Reload Error Counter for ECC SEC Error from on-chip SRAM/Fifo from <NV_DLA>.<FALCON>.<IMEM>
////1'b0 -> Do Nothing
";
        enum ERRSLICE1_COUNTER_RELOAD_ERR62_enum {
            NORELOAD = 1'd0;
            RELOAD = 1'd1;
        };
        field {
            encode          = ERRSLICE1_COUNTER_RELOAD_ERR62_enum;
            sw              = w;
            hw              = r;
            spec_access     = w;
            reset           = 0x0;
            reset_mask      = 0x1;
            spec_sw_default = 0x0;
            sw_default_mask = 0x0;
        } ERR62[30:30];
        ERR62->desc="
////1'b1 -> Reload Error Counter for ECC DED Error from on-chip SRAM/Fifo from <NV_DLA>.<RUBIK>.<FIFO_B>
////1'b0 -> Do Nothing
";
        enum ERRSLICE1_COUNTER_RELOAD_ERR61_enum {
            NORELOAD = 1'd0;
            RELOAD = 1'd1;
        };
        field {
            encode          = ERRSLICE1_COUNTER_RELOAD_ERR61_enum;
            sw              = w;
            hw              = r;
            spec_access     = w;
            reset           = 0x0;
            reset_mask      = 0x1;
            spec_sw_default = 0x0;
            sw_default_mask = 0x0;
        } ERR61[29:29];
        ERR61->desc="
////1'b1 -> Reload Error Counter for ECC SEC Error from on-chip SRAM/Fifo from <NV_DLA>.<RUBIK>.<FIFO_B>
////1'b0 -> Do Nothing
";
        enum ERRSLICE1_COUNTER_RELOAD_ERR60_enum {
            NORELOAD = 1'd0;
            RELOAD = 1'd1;
        };
        field {
            encode          = ERRSLICE1_COUNTER_RELOAD_ERR60_enum;
            sw              = w;
            hw              = r;
            spec_access     = w;
            reset           = 0x0;
            reset_mask      = 0x1;
            spec_sw_default = 0x0;
            sw_default_mask = 0x0;
        } ERR60[28:28];
        ERR60->desc="
////1'b1 -> Reload Error Counter for ECC DED Error from on-chip SRAM/Fifo from <NV_DLA>.<RUBIK>.<FIFO_A>
////1'b0 -> Do Nothing
";
        enum ERRSLICE1_COUNTER_RELOAD_ERR59_enum {
            NORELOAD = 1'd0;
            RELOAD = 1'd1;
        };
        field {
            encode          = ERRSLICE1_COUNTER_RELOAD_ERR59_enum;
            sw              = w;
            hw              = r;
            spec_access     = w;
            reset           = 0x0;
            reset_mask      = 0x1;
            spec_sw_default = 0x0;
            sw_default_mask = 0x0;
        } ERR59[27:27];
        ERR59->desc="
////1'b1 -> Reload Error Counter for ECC SEC Error from on-chip SRAM/Fifo from <NV_DLA>.<RUBIK>.<FIFO_A>
////1'b0 -> Do Nothing
";
        enum ERRSLICE1_COUNTER_RELOAD_ERR58_enum {
            NORELOAD = 1'd0;
            RELOAD = 1'd1;
        };
        field {
            encode          = ERRSLICE1_COUNTER_RELOAD_ERR58_enum;
            sw              = w;
            hw              = r;
            spec_access     = w;
            reset           = 0x0;
            reset_mask      = 0x1;
            spec_sw_default = 0x0;
            sw_default_mask = 0x0;
        } ERR58[26:26];
        ERR58->desc="
////1'b1 -> Reload Error Counter for ECC DED Error from on-chip SRAM/Fifo from <NV_DLA>.<CDP>
////1'b0 -> Do Nothing
";
        enum ERRSLICE1_COUNTER_RELOAD_ERR57_enum {
            NORELOAD = 1'd0;
            RELOAD = 1'd1;
        };
        field {
            encode          = ERRSLICE1_COUNTER_RELOAD_ERR57_enum;
            sw              = w;
            hw              = r;
            spec_access     = w;
            reset           = 0x0;
            reset_mask      = 0x1;
            spec_sw_default = 0x0;
            sw_default_mask = 0x0;
        } ERR57[25:25];
        ERR57->desc="
////1'b1 -> Reload Error Counter for ECC SEC Error from on-chip SRAM/Fifo from <NV_DLA>.<CDP>
////1'b0 -> Do Nothing
";
        enum ERRSLICE1_COUNTER_RELOAD_ERR56_enum {
            NORELOAD = 1'd0;
            RELOAD = 1'd1;
        };
        field {
            encode          = ERRSLICE1_COUNTER_RELOAD_ERR56_enum;
            sw              = w;
            hw              = r;
            spec_access     = w;
            reset           = 0x0;
            reset_mask      = 0x1;
            spec_sw_default = 0x0;
            sw_default_mask = 0x0;
        } ERR56[24:24];
        ERR56->desc="
////1'b1 -> Reload Error Counter for ECC DED Error from on-chip SRAM/Fifo from <NV_DLA>.<PDP>
////1'b0 -> Do Nothing
";
        enum ERRSLICE1_COUNTER_RELOAD_ERR55_enum {
            NORELOAD = 1'd0;
            RELOAD = 1'd1;
        };
        field {
            encode          = ERRSLICE1_COUNTER_RELOAD_ERR55_enum;
            sw              = w;
            hw              = r;
            spec_access     = w;
            reset           = 0x0;
            reset_mask      = 0x1;
            spec_sw_default = 0x0;
            sw_default_mask = 0x0;
        } ERR55[23:23];
        ERR55->desc="
////1'b1 -> Reload Error Counter for ECC SEC Error from on-chip SRAM/Fifo from <NV_DLA>.<PDP>
////1'b0 -> Do Nothing
";
        enum ERRSLICE1_COUNTER_RELOAD_ERR54_enum {
            NORELOAD = 1'd0;
            RELOAD = 1'd1;
        };
        field {
            encode          = ERRSLICE1_COUNTER_RELOAD_ERR54_enum;
            sw              = w;
            hw              = r;
            spec_access     = w;
            reset           = 0x0;
            reset_mask      = 0x1;
            spec_sw_default = 0x0;
            sw_default_mask = 0x0;
        } ERR54[22:22];
        ERR54->desc="
////1'b1 -> Reload Error Counter for ECC DED Error from on-chip SRAM/Fifo from <NV_DLA>.<SDP>.<E2>
////1'b0 -> Do Nothing
";
        enum ERRSLICE1_COUNTER_RELOAD_ERR53_enum {
            NORELOAD = 1'd0;
            RELOAD = 1'd1;
        };
        field {
            encode          = ERRSLICE1_COUNTER_RELOAD_ERR53_enum;
            sw              = w;
            hw              = r;
            spec_access     = w;
            reset           = 0x0;
            reset_mask      = 0x1;
            spec_sw_default = 0x0;
            sw_default_mask = 0x0;
        } ERR53[21:21];
        ERR53->desc="
////1'b1 -> Reload Error Counter for ECC SEC Error from on-chip SRAM/Fifo from <NV_DLA>.<SDP>.<E2>
////1'b0 -> Do Nothing
";
        enum ERRSLICE1_COUNTER_RELOAD_ERR52_enum {
            NORELOAD = 1'd0;
            RELOAD = 1'd1;
        };
        field {
            encode          = ERRSLICE1_COUNTER_RELOAD_ERR52_enum;
            sw              = w;
            hw              = r;
            spec_access     = w;
            reset           = 0x0;
            reset_mask      = 0x1;
            spec_sw_default = 0x0;
            sw_default_mask = 0x0;
        } ERR52[20:20];
        ERR52->desc="
////1'b1 -> Reload Error Counter for ECC DED Error from on-chip SRAM/Fifo from <NV_DLA>.<SDP>.<N2>
////1'b0 -> Do Nothing
";
        enum ERRSLICE1_COUNTER_RELOAD_ERR51_enum {
            NORELOAD = 1'd0;
            RELOAD = 1'd1;
        };
        field {
            encode          = ERRSLICE1_COUNTER_RELOAD_ERR51_enum;
            sw              = w;
            hw              = r;
            spec_access     = w;
            reset           = 0x0;
            reset_mask      = 0x1;
            spec_sw_default = 0x0;
            sw_default_mask = 0x0;
        } ERR51[19:19];
        ERR51->desc="
////1'b1 -> Reload Error Counter for ECC SEC Error from on-chip SRAM/Fifo from <NV_DLA>.<SDP>.<N2>
////1'b0 -> Do Nothing
";
        enum ERRSLICE1_COUNTER_RELOAD_ERR50_enum {
            NORELOAD = 1'd0;
            RELOAD = 1'd1;
        };
        field {
            encode          = ERRSLICE1_COUNTER_RELOAD_ERR50_enum;
            sw              = w;
            hw              = r;
            spec_access     = w;
            reset           = 0x0;
            reset_mask      = 0x1;
            spec_sw_default = 0x0;
            sw_default_mask = 0x0;
        } ERR50[18:18];
        ERR50->desc="
////1'b1 -> Reload Error Counter for ECC DED Error from on-chip SRAM/Fifo from <NV_DLA>.<SDP>.<B2>
////1'b0 -> Do Nothing
";
        enum ERRSLICE1_COUNTER_RELOAD_ERR49_enum {
            NORELOAD = 1'd0;
            RELOAD = 1'd1;
        };
        field {
            encode          = ERRSLICE1_COUNTER_RELOAD_ERR49_enum;
            sw              = w;
            hw              = r;
            spec_access     = w;
            reset           = 0x0;
            reset_mask      = 0x1;
            spec_sw_default = 0x0;
            sw_default_mask = 0x0;
        } ERR49[17:17];
        ERR49->desc="
////1'b1 -> Reload Error Counter for ECC SEC Error from on-chip SRAM/Fifo from <NV_DLA>.<SDP>.<B2>
////1'b0 -> Do Nothing
";
        enum ERRSLICE1_COUNTER_RELOAD_ERR48_enum {
            NORELOAD = 1'd0;
            RELOAD = 1'd1;
        };
        field {
            encode          = ERRSLICE1_COUNTER_RELOAD_ERR48_enum;
            sw              = w;
            hw              = r;
            spec_access     = w;
            reset           = 0x0;
            reset_mask      = 0x1;
            spec_sw_default = 0x0;
            sw_default_mask = 0x0;
        } ERR48[16:16];
        ERR48->desc="
////1'b1 -> Reload Error Counter for ECC DED Error from on-chip SRAM/Fifo from <NV_DLA>.<SDP>
////1'b0 -> Do Nothing
";
        enum ERRSLICE1_COUNTER_RELOAD_ERR47_enum {
            NORELOAD = 1'd0;
            RELOAD = 1'd1;
        };
        field {
            encode          = ERRSLICE1_COUNTER_RELOAD_ERR47_enum;
            sw              = w;
            hw              = r;
            spec_access     = w;
            reset           = 0x0;
            reset_mask      = 0x1;
            spec_sw_default = 0x0;
            sw_default_mask = 0x0;
        } ERR47[15:15];
        ERR47->desc="
////1'b1 -> Reload Error Counter for ECC SEC Error from on-chip SRAM/Fifo from <NV_DLA>.<SDP>
////1'b0 -> Do Nothing
";
        enum ERRSLICE1_COUNTER_RELOAD_ERR46_enum {
            NORELOAD = 1'd0;
            RELOAD = 1'd1;
        };
        field {
            encode          = ERRSLICE1_COUNTER_RELOAD_ERR46_enum;
            sw              = w;
            hw              = r;
            spec_access     = w;
            reset           = 0x0;
            reset_mask      = 0x1;
            spec_sw_default = 0x0;
            sw_default_mask = 0x0;
        } ERR46[14:14];
        ERR46->desc="
////1'b1 -> Reload Error Counter for ECC DED Error from on-chip SRAM/Fifo from <NV_DLA>.<CACC>.<D7BUF>
////1'b0 -> Do Nothing
";
        enum ERRSLICE1_COUNTER_RELOAD_ERR45_enum {
            NORELOAD = 1'd0;
            RELOAD = 1'd1;
        };
        field {
            encode          = ERRSLICE1_COUNTER_RELOAD_ERR45_enum;
            sw              = w;
            hw              = r;
            spec_access     = w;
            reset           = 0x0;
            reset_mask      = 0x1;
            spec_sw_default = 0x0;
            sw_default_mask = 0x0;
        } ERR45[13:13];
        ERR45->desc="
////1'b1 -> Reload Error Counter for ECC SEC Error from on-chip SRAM/Fifo from <NV_DLA>.<CACC>.<D7BUF>
////1'b0 -> Do Nothing
";
        enum ERRSLICE1_COUNTER_RELOAD_ERR44_enum {
            NORELOAD = 1'd0;
            RELOAD = 1'd1;
        };
        field {
            encode          = ERRSLICE1_COUNTER_RELOAD_ERR44_enum;
            sw              = w;
            hw              = r;
            spec_access     = w;
            reset           = 0x0;
            reset_mask      = 0x1;
            spec_sw_default = 0x0;
            sw_default_mask = 0x0;
        } ERR44[12:12];
        ERR44->desc="
////1'b1 -> Reload Error Counter for ECC DED Error from on-chip SRAM/Fifo from <NV_DLA>.<CACC>.<D6BUF>
////1'b0 -> Do Nothing
";
        enum ERRSLICE1_COUNTER_RELOAD_ERR43_enum {
            NORELOAD = 1'd0;
            RELOAD = 1'd1;
        };
        field {
            encode          = ERRSLICE1_COUNTER_RELOAD_ERR43_enum;
            sw              = w;
            hw              = r;
            spec_access     = w;
            reset           = 0x0;
            reset_mask      = 0x1;
            spec_sw_default = 0x0;
            sw_default_mask = 0x0;
        } ERR43[11:11];
        ERR43->desc="
////1'b1 -> Reload Error Counter for ECC SEC Error from on-chip SRAM/Fifo from <NV_DLA>.<CACC>.<D6BUF>
////1'b0 -> Do Nothing
";
        enum ERRSLICE1_COUNTER_RELOAD_ERR42_enum {
            NORELOAD = 1'd0;
            RELOAD = 1'd1;
        };
        field {
            encode          = ERRSLICE1_COUNTER_RELOAD_ERR42_enum;
            sw              = w;
            hw              = r;
            spec_access     = w;
            reset           = 0x0;
            reset_mask      = 0x1;
            spec_sw_default = 0x0;
            sw_default_mask = 0x0;
        } ERR42[10:10];
        ERR42->desc="
////1'b1 -> Reload Error Counter for ECC DED Error from on-chip SRAM/Fifo from <NV_DLA>.<CACC>.<D5BUF>
////1'b0 -> Do Nothing
";
        enum ERRSLICE1_COUNTER_RELOAD_ERR41_enum {
            NORELOAD = 1'd0;
            RELOAD = 1'd1;
        };
        field {
            encode          = ERRSLICE1_COUNTER_RELOAD_ERR41_enum;
            sw              = w;
            hw              = r;
            spec_access     = w;
            reset           = 0x0;
            reset_mask      = 0x1;
            spec_sw_default = 0x0;
            sw_default_mask = 0x0;
        } ERR41[9:9];
        ERR41->desc="
////1'b1 -> Reload Error Counter for ECC SEC Error from on-chip SRAM/Fifo from <NV_DLA>.<CACC>.<D5BUF>
////1'b0 -> Do Nothing
";
        enum ERRSLICE1_COUNTER_RELOAD_ERR40_enum {
            NORELOAD = 1'd0;
            RELOAD = 1'd1;
        };
        field {
            encode          = ERRSLICE1_COUNTER_RELOAD_ERR40_enum;
            sw              = w;
            hw              = r;
            spec_access     = w;
            reset           = 0x0;
            reset_mask      = 0x1;
            spec_sw_default = 0x0;
            sw_default_mask = 0x0;
        } ERR40[8:8];
        ERR40->desc="
////1'b1 -> Reload Error Counter for ECC DED Error from on-chip SRAM/Fifo from <NV_DLA>.<CACC>.<D4BUF>
////1'b0 -> Do Nothing
";
        enum ERRSLICE1_COUNTER_RELOAD_ERR39_enum {
            NORELOAD = 1'd0;
            RELOAD = 1'd1;
        };
        field {
            encode          = ERRSLICE1_COUNTER_RELOAD_ERR39_enum;
            sw              = w;
            hw              = r;
            spec_access     = w;
            reset           = 0x0;
            reset_mask      = 0x1;
            spec_sw_default = 0x0;
            sw_default_mask = 0x0;
        } ERR39[7:7];
        ERR39->desc="
////1'b1 -> Reload Error Counter for ECC SEC Error from on-chip SRAM/Fifo from <NV_DLA>.<CACC>.<D4BUF>
////1'b0 -> Do Nothing
";
        enum ERRSLICE1_COUNTER_RELOAD_ERR38_enum {
            NORELOAD = 1'd0;
            RELOAD = 1'd1;
        };
        field {
            encode          = ERRSLICE1_COUNTER_RELOAD_ERR38_enum;
            sw              = w;
            hw              = r;
            spec_access     = w;
            reset           = 0x0;
            reset_mask      = 0x1;
            spec_sw_default = 0x0;
            sw_default_mask = 0x0;
        } ERR38[6:6];
        ERR38->desc="
////1'b1 -> Reload Error Counter for ECC DED Error from on-chip SRAM/Fifo from <NV_DLA>.<CACC>.<D3BUF>
////1'b0 -> Do Nothing
";
        enum ERRSLICE1_COUNTER_RELOAD_ERR37_enum {
            NORELOAD = 1'd0;
            RELOAD = 1'd1;
        };
        field {
            encode          = ERRSLICE1_COUNTER_RELOAD_ERR37_enum;
            sw              = w;
            hw              = r;
            spec_access     = w;
            reset           = 0x0;
            reset_mask      = 0x1;
            spec_sw_default = 0x0;
            sw_default_mask = 0x0;
        } ERR37[5:5];
        ERR37->desc="
////1'b1 -> Reload Error Counter for ECC SEC Error from on-chip SRAM/Fifo from <NV_DLA>.<CACC>.<D3BUF>
////1'b0 -> Do Nothing
";
        enum ERRSLICE1_COUNTER_RELOAD_ERR36_enum {
            NORELOAD = 1'd0;
            RELOAD = 1'd1;
        };
        field {
            encode          = ERRSLICE1_COUNTER_RELOAD_ERR36_enum;
            sw              = w;
            hw              = r;
            spec_access     = w;
            reset           = 0x0;
            reset_mask      = 0x1;
            spec_sw_default = 0x0;
            sw_default_mask = 0x0;
        } ERR36[4:4];
        ERR36->desc="
////1'b1 -> Reload Error Counter for ECC DED Error from on-chip SRAM/Fifo from <NV_DLA>.<CACC>.<D2BUF>
////1'b0 -> Do Nothing
";
        enum ERRSLICE1_COUNTER_RELOAD_ERR35_enum {
            NORELOAD = 1'd0;
            RELOAD = 1'd1;
        };
        field {
            encode          = ERRSLICE1_COUNTER_RELOAD_ERR35_enum;
            sw              = w;
            hw              = r;
            spec_access     = w;
            reset           = 0x0;
            reset_mask      = 0x1;
            spec_sw_default = 0x0;
            sw_default_mask = 0x0;
        } ERR35[3:3];
        ERR35->desc="
////1'b1 -> Reload Error Counter for ECC SEC Error from on-chip SRAM/Fifo from <NV_DLA>.<CACC>.<D2BUF>
////1'b0 -> Do Nothing
";
        enum ERRSLICE1_COUNTER_RELOAD_ERR34_enum {
            NORELOAD = 1'd0;
            RELOAD = 1'd1;
        };
        field {
            encode          = ERRSLICE1_COUNTER_RELOAD_ERR34_enum;
            sw              = w;
            hw              = r;
            spec_access     = w;
            reset           = 0x0;
            reset_mask      = 0x1;
            spec_sw_default = 0x0;
            sw_default_mask = 0x0;
        } ERR34[2:2];
        ERR34->desc="
////1'b1 -> Reload Error Counter for ECC DED Error from on-chip SRAM/Fifo from <NV_DLA>.<CACC>.<D1BUF>
////1'b0 -> Do Nothing
";
        enum ERRSLICE1_COUNTER_RELOAD_ERR33_enum {
            NORELOAD = 1'd0;
            RELOAD = 1'd1;
        };
        field {
            encode          = ERRSLICE1_COUNTER_RELOAD_ERR33_enum;
            sw              = w;
            hw              = r;
            spec_access     = w;
            reset           = 0x0;
            reset_mask      = 0x1;
            spec_sw_default = 0x0;
            sw_default_mask = 0x0;
        } ERR33[1:1];
        ERR33->desc="
////1'b1 -> Reload Error Counter for ECC SEC Error from on-chip SRAM/Fifo from <NV_DLA>.<CACC>.<D1BUF>
////1'b0 -> Do Nothing
";
        enum ERRSLICE1_COUNTER_RELOAD_ERR32_enum {
            NORELOAD = 1'd0;
            RELOAD = 1'd1;
        };
        field {
            encode          = ERRSLICE1_COUNTER_RELOAD_ERR32_enum;
            sw              = w;
            hw              = r;
            spec_access     = w;
            reset           = 0x0;
            reset_mask      = 0x1;
            spec_sw_default = 0x0;
            sw_default_mask = 0x0;
        } ERR32[0:0];
        ERR32->desc="
////1'b1 -> Reload Error Counter for ECC DED Error from on-chip SRAM/Fifo from <NV_DLA>.<CACC>.<D0BUF>
////1'b0 -> Do Nothing
";
    }ERRSLICE1_COUNTER_RELOAD @0x80;
    reg {
        name = "ERRSLICE1_MISSIONERR_ECC_CORRECTION_DIS";
        enum ERRSLICE1_MISSIONERR_ECC_CORRECTION_DIS_ERR63_enum {
            DISABLE = 1'd0;
            ENABLE = 1'd1;
        };
        field {
            encode          = ERRSLICE1_MISSIONERR_ECC_CORRECTION_DIS_ERR63_enum;
            sw              = rw;
            hw              = r;
            spec_access     = rw;
            reset           = 0x0;
            reset_mask      = 0x1;
            spec_sw_default = 0x0;
            sw_default_mask = 0x0;
        } ERR63[31:31];
        ERR63->desc="
////1'b1 -> Disables ECC correction in ECC Terminate plugins for <NV_DLA>.<FALCON>.<IMEM> and shall report single bit errors over the ded_err_pulse[1:0] to only allow detection and no correction.
////1'b0 -> ECC correction is enabled in ECC terminate plugins for <NV_DLA>.<FALCON>.<IMEM> and shall correct single bit errors and report them over sec_err_pulse[1:0]
";
    }ERRSLICE1_MISSIONERR_ECC_CORRECTION_DIS @0x84;
    reg {
        name = "ERRSLICE2_MISSIONERR_ENABLE";
        desc = "
//// 0x28 to 0x30 = Reserved for future use.
////==================================
//// ERROR SLICE - 2
////==================================
";
        enum ERRSLICE2_MISSIONERR_ENABLE_ERR67_enum {
            DISABLE = 1'd0;
            ENABLE = 1'd1;
        };
        field {
            encode          = ERRSLICE2_MISSIONERR_ENABLE_ERR67_enum;
            sw              = rw;
            hw              = r;
            spec_access     = rw;
            reset           = 0x1;
            reset_mask      = 0x1;
            spec_sw_default = 0x0;
            sw_default_mask = 0x0;
        } ERR67[3:3];
        ERR67->desc="
////1'b1 -> Enable  Mission Error Reporting for SW Uncorrectabel Error from <NV_DLA>.<FALCON>.<ERB>
////1'b0 -> Disable Mission Error Reporting for SW Uncorrectabel Error from <NV_DLA>.<FALCON>.<ERB>
";
        enum ERRSLICE2_MISSIONERR_ENABLE_ERR66_enum {
            DISABLE = 1'd0;
            ENABLE = 1'd1;
        };
        field {
            encode          = ERRSLICE2_MISSIONERR_ENABLE_ERR66_enum;
            sw              = rw;
            hw              = r;
            spec_access     = rw;
            reset           = 0x1;
            reset_mask      = 0x1;
            spec_sw_default = 0x0;
            sw_default_mask = 0x0;
        } ERR66[2:2];
        ERR66->desc="
////1'b1 -> Enable  Mission Error Reporting for SW Correctable Error from <NV_DLA>.<FALCON>.<ERB>
////1'b0 -> Disable Mission Error Reporting for SW Correctable Error from <NV_DLA>.<FALCON>.<ERB>
";
        enum ERRSLICE2_MISSIONERR_ENABLE_ERR65_enum {
            DISABLE = 1'd0;
            ENABLE = 1'd1;
        };
        field {
            encode          = ERRSLICE2_MISSIONERR_ENABLE_ERR65_enum;
            sw              = rw;
            hw              = r;
            spec_access     = rw;
            reset           = 0x1;
            reset_mask      = 0x1;
            spec_sw_default = 0x0;
            sw_default_mask = 0x0;
        } ERR65[1:1];
        ERR65->desc="
////1'b1 -> Enable  Mission Error Reporting for Parity Error from on-chip SRAM/Fifo from <NV_DLA>.<FALCON>.<DMEM>
////1'b0 -> Disable Mission Error Reporting for Parity Error from on-chip SRAM/Fifo from <NV_DLA>.<FALCON>.<DMEM>
";
        enum ERRSLICE2_MISSIONERR_ENABLE_ERR64_enum {
            DISABLE = 1'd0;
            ENABLE = 1'd1;
        };
        field {
            encode          = ERRSLICE2_MISSIONERR_ENABLE_ERR64_enum;
            sw              = rw;
            hw              = r;
            spec_access     = rw;
            reset           = 0x1;
            reset_mask      = 0x1;
            spec_sw_default = 0x0;
            sw_default_mask = 0x0;
        } ERR64[0:0];
        ERR64->desc="
////1'b1 -> Enable  Mission Error Reporting for ECC DED Error from on-chip SRAM/Fifo from <NV_DLA>.<FALCON>.<IMEM>
////1'b0 -> Disable Mission Error Reporting for ECC DED Error from on-chip SRAM/Fifo from <NV_DLA>.<FALCON>.<IMEM>
";
    }ERRSLICE2_MISSIONERR_ENABLE @0x90;
    reg {
        name = "ERRSLICE2_MISSIONERR_FORCE";
        enum ERRSLICE2_MISSIONERR_FORCE_ERR67_enum {
            NOFORCE = 1'd0;
            FORCE = 1'd1;
        };
        field {
            encode          = ERRSLICE2_MISSIONERR_FORCE_ERR67_enum;
            sw              = w;
            hw              = r;
            spec_access     = w;
            reset           = 0x0;
            reset_mask      = 0x1;
            spec_sw_default = 0x0;
            sw_default_mask = 0x0;
        } ERR67[3:3];
        ERR67->desc="
////1'b1 -> Force Assertion of Mission Error Reporting for SW Uncorrectabel Error from <NV_DLA>.<FALCON>.<ERB>
////1'b0 -> Do Nothing
";
        enum ERRSLICE2_MISSIONERR_FORCE_ERR66_enum {
            NOFORCE = 1'd0;
            FORCE = 1'd1;
        };
        field {
            encode          = ERRSLICE2_MISSIONERR_FORCE_ERR66_enum;
            sw              = w;
            hw              = r;
            spec_access     = w;
            reset           = 0x0;
            reset_mask      = 0x1;
            spec_sw_default = 0x0;
            sw_default_mask = 0x0;
        } ERR66[2:2];
        ERR66->desc="
////1'b1 -> Force Assertion of Mission Error Reporting for SW Correctable Error from <NV_DLA>.<FALCON>.<ERB>
////1'b0 -> Do Nothing
";
        enum ERRSLICE2_MISSIONERR_FORCE_ERR65_enum {
            NOFORCE = 1'd0;
            FORCE = 1'd1;
        };
        field {
            encode          = ERRSLICE2_MISSIONERR_FORCE_ERR65_enum;
            sw              = w;
            hw              = r;
            spec_access     = w;
            reset           = 0x0;
            reset_mask      = 0x1;
            spec_sw_default = 0x0;
            sw_default_mask = 0x0;
        } ERR65[1:1];
        ERR65->desc="
////1'b1 -> Force Assertion of Mission Error Reporting for Parity Error from on-chip SRAM/Fifo from <NV_DLA>.<FALCON>.<DMEM>
////1'b0 -> Do Nothing
";
        enum ERRSLICE2_MISSIONERR_FORCE_ERR64_enum {
            NOFORCE = 1'd0;
            FORCE = 1'd1;
        };
        field {
            encode          = ERRSLICE2_MISSIONERR_FORCE_ERR64_enum;
            sw              = w;
            hw              = r;
            spec_access     = w;
            reset           = 0x0;
            reset_mask      = 0x1;
            spec_sw_default = 0x0;
            sw_default_mask = 0x0;
        } ERR64[0:0];
        ERR64->desc="
////1'b1 -> Force Assertion of Mission Error Reporting for ECC DED Error from on-chip SRAM/Fifo from <NV_DLA>.<FALCON>.<IMEM>
////1'b0 -> Do Nothing
";
    }ERRSLICE2_MISSIONERR_FORCE @0x94;
    reg {
        name = "ERRSLICE2_MISSIONERR_STATUS";
        desc = "
////SW must write 1 to clear the fields of this register.
////Bits in this register continue to be logged independent of the value of MissionError_Enable register, to avoid silent dropping of errors.
";
        field {
            sw              = rw;
            hw              = r;
            spec_access     = rw;
            reset           = 0x0;
            reset_mask      = 0x1;
            spec_sw_default = 0x0;
            sw_default_mask = 0x0;
        } ERR67[3:3];
        ERR67->desc="
////1'b1 -> Error_67_pulse[1:0] for SW Uncorrectabel Error from <NV_DLA>.<FALCON>.<ERB> was equal to 2'b10.
////1'b0 -> Error_67_pulse[1:0] for SW Uncorrectabel Error from <NV_DLA>.<FALCON>.<ERB> was equal to 2'b01.
";
        field {
            sw              = rw;
            hw              = r;
            spec_access     = rw;
            reset           = 0x0;
            reset_mask      = 0x1;
            spec_sw_default = 0x0;
            sw_default_mask = 0x0;
        } ERR66[2:2];
        ERR66->desc="
////1'b1 -> Error_66_pulse[1:0] for SW Correctable Error from <NV_DLA>.<FALCON>.<ERB> was equal to 2'b10.
////1'b0 -> Error_66_pulse[1:0] for SW Correctable Error from <NV_DLA>.<FALCON>.<ERB> was equal to 2'b01.
";
        field {
            sw              = rw;
            hw              = r;
            spec_access     = rw;
            reset           = 0x0;
            reset_mask      = 0x1;
            spec_sw_default = 0x0;
            sw_default_mask = 0x0;
        } ERR65[1:1];
        ERR65->desc="
////1'b1 -> Error_65_pulse[1:0] for Parity Error from on-chip SRAM/Fifo from <NV_DLA>.<FALCON>.<DMEM> was equal to 2'b10.
////1'b0 -> Error_65_pulse[1:0] for Parity Error from on-chip SRAM/Fifo from <NV_DLA>.<FALCON>.<DMEM> was equal to 2'b01.
";
        field {
            sw              = rw;
            hw              = r;
            spec_access     = rw;
            reset           = 0x0;
            reset_mask      = 0x1;
            spec_sw_default = 0x0;
            sw_default_mask = 0x0;
        } ERR64[0:0];
        ERR64->desc="
////1'b1 -> Error_64_pulse[1:0] for ECC DED Error from on-chip SRAM/Fifo from <NV_DLA>.<FALCON>.<IMEM> was equal to 2'b10.
////1'b0 -> Error_64_pulse[1:0] for ECC DED Error from on-chip SRAM/Fifo from <NV_DLA>.<FALCON>.<IMEM> was equal to 2'b01.
";
    }ERRSLICE2_MISSIONERR_STATUS @0x98;
    reg {
        name = "ERRSLICE2_MISSIONERR_INJECT";
        enum ERRSLICE2_MISSIONERR_INJECT_ERR65_enum {
            DISABLE = 1'd0;
            ENABLE = 1'd1;
        };
        field {
            encode          = ERRSLICE2_MISSIONERR_INJECT_ERR65_enum;
            sw              = rw;
            hw              = r;
            spec_access     = rw;
            reset           = 0x0;
            reset_mask      = 0x1;
            spec_sw_default = 0x0;
            sw_default_mask = 0x0;
        } ERR65[1:1];
        ERR65->desc="
////1'b1 -> Assert the inject_error_65 output for Parity Error from on-chip SRAM/Fifo to <NV_DLA>.<FALCON>.<DMEM> to allow for error injection.
////1'b0 -> De-Asseert inject_error_65 output.
";
        enum ERRSLICE2_MISSIONERR_INJECT_ERR64_enum {
            DISABLE = 1'd0;
            ENABLE = 1'd1;
        };
        field {
            encode          = ERRSLICE2_MISSIONERR_INJECT_ERR64_enum;
            sw              = rw;
            hw              = r;
            spec_access     = rw;
            reset           = 0x0;
            reset_mask      = 0x1;
            spec_sw_default = 0x0;
            sw_default_mask = 0x0;
        } ERR64[0:0];
        ERR64->desc="
////1'b1 -> Assert the inject_error_64 output for ECC DED Error from on-chip SRAM/Fifo to <NV_DLA>.<FALCON>.<IMEM> to allow for error injection.
////1'b0 -> De-Asseert inject_error_64 output.
";
    }ERRSLICE2_MISSIONERR_INJECT @0x9c;
    reg {
        name = "ERRSLICE2_LATENTERR_ENABLE";
        enum ERRSLICE2_LATENTERR_ENABLE_ERR67_enum {
            DISABLE = 1'd0;
            ENABLE = 1'd1;
        };
        field {
            encode          = ERRSLICE2_LATENTERR_ENABLE_ERR67_enum;
            sw              = rw;
            hw              = r;
            spec_access     = rw;
            reset           = 0x1;
            reset_mask      = 0x1;
            spec_sw_default = 0x0;
            sw_default_mask = 0x0;
        } ERR67[3:3];
        ERR67->desc="
////1'b1 -> Enable  Latent Error Reporting for SW Uncorrectabel Error from <NV_DLA>.<FALCON>.<ERB>
////1'b0 -> Disable Latent Error Reporting for SW Uncorrectabel Error from <NV_DLA>.<FALCON>.<ERB>
";
        enum ERRSLICE2_LATENTERR_ENABLE_ERR66_enum {
            DISABLE = 1'd0;
            ENABLE = 1'd1;
        };
        field {
            encode          = ERRSLICE2_LATENTERR_ENABLE_ERR66_enum;
            sw              = rw;
            hw              = r;
            spec_access     = rw;
            reset           = 0x1;
            reset_mask      = 0x1;
            spec_sw_default = 0x0;
            sw_default_mask = 0x0;
        } ERR66[2:2];
        ERR66->desc="
////1'b1 -> Enable  Latent Error Reporting for SW Correctable Error from <NV_DLA>.<FALCON>.<ERB>
////1'b0 -> Disable Latent Error Reporting for SW Correctable Error from <NV_DLA>.<FALCON>.<ERB>
";
        enum ERRSLICE2_LATENTERR_ENABLE_ERR65_enum {
            DISABLE = 1'd0;
            ENABLE = 1'd1;
        };
        field {
            encode          = ERRSLICE2_LATENTERR_ENABLE_ERR65_enum;
            sw              = rw;
            hw              = r;
            spec_access     = rw;
            reset           = 0x1;
            reset_mask      = 0x1;
            spec_sw_default = 0x0;
            sw_default_mask = 0x0;
        } ERR65[1:1];
        ERR65->desc="
////1'b1 -> Enable  Latent Error Reporting for Parity Error from on-chip SRAM/Fifo from <NV_DLA>.<FALCON>.<DMEM>
////1'b0 -> Disable Latent Error Reporting for Parity Error from on-chip SRAM/Fifo from <NV_DLA>.<FALCON>.<DMEM>
";
        enum ERRSLICE2_LATENTERR_ENABLE_ERR64_enum {
            DISABLE = 1'd0;
            ENABLE = 1'd1;
        };
        field {
            encode          = ERRSLICE2_LATENTERR_ENABLE_ERR64_enum;
            sw              = rw;
            hw              = r;
            spec_access     = rw;
            reset           = 0x1;
            reset_mask      = 0x1;
            spec_sw_default = 0x0;
            sw_default_mask = 0x0;
        } ERR64[0:0];
        ERR64->desc="
////1'b1 -> Enable  Latent Error Reporting for ECC DED Error from on-chip SRAM/Fifo from <NV_DLA>.<FALCON>.<IMEM>
////1'b0 -> Disable Latent Error Reporting for ECC DED Error from on-chip SRAM/Fifo from <NV_DLA>.<FALCON>.<IMEM>
";
    }ERRSLICE2_LATENTERR_ENABLE @0xa0;
    reg {
        name = "ERRSLICE2_LATENTERR_FORCE";
        enum ERRSLICE2_LATENTERR_FORCE_ERR67_enum {
            NOFORCE = 1'd0;
            FORCE = 1'd1;
        };
        field {
            encode          = ERRSLICE2_LATENTERR_FORCE_ERR67_enum;
            sw              = w;
            hw              = r;
            spec_access     = w;
            reset           = 0x0;
            reset_mask      = 0x1;
            spec_sw_default = 0x0;
            sw_default_mask = 0x0;
        } ERR67[3:3];
        ERR67->desc="
////1'b1 -> Force Assertion of Latent Error Reporting for SW Uncorrectabel Error from <NV_DLA>.<FALCON>.<ERB>
////1'b0 -> Do Nothing
";
        enum ERRSLICE2_LATENTERR_FORCE_ERR66_enum {
            NOFORCE = 1'd0;
            FORCE = 1'd1;
        };
        field {
            encode          = ERRSLICE2_LATENTERR_FORCE_ERR66_enum;
            sw              = w;
            hw              = r;
            spec_access     = w;
            reset           = 0x0;
            reset_mask      = 0x1;
            spec_sw_default = 0x0;
            sw_default_mask = 0x0;
        } ERR66[2:2];
        ERR66->desc="
////1'b1 -> Force Assertion of Latent Error Reporting for SW Correctable Error from <NV_DLA>.<FALCON>.<ERB>
////1'b0 -> Do Nothing
";
        enum ERRSLICE2_LATENTERR_FORCE_ERR65_enum {
            NOFORCE = 1'd0;
            FORCE = 1'd1;
        };
        field {
            encode          = ERRSLICE2_LATENTERR_FORCE_ERR65_enum;
            sw              = w;
            hw              = r;
            spec_access     = w;
            reset           = 0x0;
            reset_mask      = 0x1;
            spec_sw_default = 0x0;
            sw_default_mask = 0x0;
        } ERR65[1:1];
        ERR65->desc="
////1'b1 -> Force Assertion of Latent Error Reporting for Parity Error from on-chip SRAM/Fifo from <NV_DLA>.<FALCON>.<DMEM>
////1'b0 -> Do Nothing
";
        enum ERRSLICE2_LATENTERR_FORCE_ERR64_enum {
            NOFORCE = 1'd0;
            FORCE = 1'd1;
        };
        field {
            encode          = ERRSLICE2_LATENTERR_FORCE_ERR64_enum;
            sw              = w;
            hw              = r;
            spec_access     = w;
            reset           = 0x0;
            reset_mask      = 0x1;
            spec_sw_default = 0x0;
            sw_default_mask = 0x0;
        } ERR64[0:0];
        ERR64->desc="
////1'b1 -> Force Assertion of Latent Error Reporting for ECC DED Error from on-chip SRAM/Fifo from <NV_DLA>.<FALCON>.<IMEM>
////1'b0 -> Do Nothing
";
    }ERRSLICE2_LATENTERR_FORCE @0xa4;
    reg {
        name = "ERRSLICE2_LATENTERR_STATUS";
        desc = "
////SW must write 1 to clear the fields of this register.
////Bits in this register continue to be logged independent of the value of LatentError_Enable register, to avoid silent dropping of errors.
";
        field {
            sw              = rw;
            hw              = r;
            spec_access     = rw;
            reset           = 0x0;
            reset_mask      = 0x1;
            spec_sw_default = 0x0;
            sw_default_mask = 0x0;
        } ERR67[3:3];
        ERR67->desc="
////1'b1 -> Error_67_pulse[1:0] for SW Uncorrectabel Error from <NV_DLA>.<FALCON>.<ERB> was equal to 2'b10.
////1'b0 -> Error_67_pulse[1:0] for SW Uncorrectabel Error from <NV_DLA>.<FALCON>.<ERB> was equal to 2'b01.
";
        field {
            sw              = rw;
            hw              = r;
            spec_access     = rw;
            reset           = 0x0;
            reset_mask      = 0x1;
            spec_sw_default = 0x0;
            sw_default_mask = 0x0;
        } ERR66[2:2];
        ERR66->desc="
////1'b1 -> Error_66_pulse[1:0] for SW Correctable Error from <NV_DLA>.<FALCON>.<ERB> was equal to 2'b10.
////1'b0 -> Error_66_pulse[1:0] for SW Correctable Error from <NV_DLA>.<FALCON>.<ERB> was equal to 2'b01.
";
        field {
            sw              = rw;
            hw              = r;
            spec_access     = rw;
            reset           = 0x0;
            reset_mask      = 0x1;
            spec_sw_default = 0x0;
            sw_default_mask = 0x0;
        } ERR65[1:1];
        ERR65->desc="
////1'b1 -> Error_65_pulse[1:0] for Parity Error from on-chip SRAM/Fifo from <NV_DLA>.<FALCON>.<DMEM> was equal to 2'b10.
////1'b0 -> Error_65_pulse[1:0] for Parity Error from on-chip SRAM/Fifo from <NV_DLA>.<FALCON>.<DMEM> was equal to 2'b01.
";
        field {
            sw              = rw;
            hw              = r;
            spec_access     = rw;
            reset           = 0x0;
            reset_mask      = 0x1;
            spec_sw_default = 0x0;
            sw_default_mask = 0x0;
        } ERR64[0:0];
        ERR64->desc="
////1'b1 -> Error_64_pulse[1:0] for ECC DED Error from on-chip SRAM/Fifo from <NV_DLA>.<FALCON>.<IMEM> was equal to 2'b10.
////1'b0 -> Error_64_pulse[1:0] for ECC DED Error from on-chip SRAM/Fifo from <NV_DLA>.<FALCON>.<IMEM> was equal to 2'b01.
";
    }ERRSLICE2_LATENTERR_STATUS @0xa8;
    reg {
        name = "ERRSLICE2_COUNTER_RELOAD";
        enum ERRSLICE2_COUNTER_RELOAD_ERR67_enum {
            NORELOAD = 1'd0;
            RELOAD = 1'd1;
        };
        field {
            encode          = ERRSLICE2_COUNTER_RELOAD_ERR67_enum;
            sw              = w;
            hw              = r;
            spec_access     = w;
            reset           = 0x0;
            reset_mask      = 0x1;
            spec_sw_default = 0x0;
            sw_default_mask = 0x0;
        } ERR67[3:3];
        ERR67->desc="
////1'b1 -> Reload Error Counter for SW Uncorrectabel Error from <NV_DLA>.<FALCON>.<ERB>
////1'b0 -> Do Nothing
";
        enum ERRSLICE2_COUNTER_RELOAD_ERR66_enum {
            NORELOAD = 1'd0;
            RELOAD = 1'd1;
        };
        field {
            encode          = ERRSLICE2_COUNTER_RELOAD_ERR66_enum;
            sw              = w;
            hw              = r;
            spec_access     = w;
            reset           = 0x0;
            reset_mask      = 0x1;
            spec_sw_default = 0x0;
            sw_default_mask = 0x0;
        } ERR66[2:2];
        ERR66->desc="
////1'b1 -> Reload Error Counter for SW Correctable Error from <NV_DLA>.<FALCON>.<ERB>
////1'b0 -> Do Nothing
";
        enum ERRSLICE2_COUNTER_RELOAD_ERR65_enum {
            NORELOAD = 1'd0;
            RELOAD = 1'd1;
        };
        field {
            encode          = ERRSLICE2_COUNTER_RELOAD_ERR65_enum;
            sw              = w;
            hw              = r;
            spec_access     = w;
            reset           = 0x0;
            reset_mask      = 0x1;
            spec_sw_default = 0x0;
            sw_default_mask = 0x0;
        } ERR65[1:1];
        ERR65->desc="
////1'b1 -> Reload Error Counter for Parity Error from on-chip SRAM/Fifo from <NV_DLA>.<FALCON>.<DMEM>
////1'b0 -> Do Nothing
";
        enum ERRSLICE2_COUNTER_RELOAD_ERR64_enum {
            NORELOAD = 1'd0;
            RELOAD = 1'd1;
        };
        field {
            encode          = ERRSLICE2_COUNTER_RELOAD_ERR64_enum;
            sw              = w;
            hw              = r;
            spec_access     = w;
            reset           = 0x0;
            reset_mask      = 0x1;
            spec_sw_default = 0x0;
            sw_default_mask = 0x0;
        } ERR64[0:0];
        ERR64->desc="
////1'b1 -> Reload Error Counter for ECC DED Error from on-chip SRAM/Fifo from <NV_DLA>.<FALCON>.<IMEM>
////1'b0 -> Do Nothing
";
    }ERRSLICE2_COUNTER_RELOAD @0xb0;
};
addrmap  {
    regs_NVDLA_GEC NVDLA_GEC @0xe000;
}addrmap_NVDLA;
