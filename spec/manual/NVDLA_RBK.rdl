// ================================================================
// NVDLA Open Source Project
// 
// Copyright(c) 2016 - 2017 NVIDIA Corporation.  Licensed under the
// NVDLA Open Hardware License; Check "LICENSE" which comes with 
// this distribution for more information.
// ================================================================

property spec_sw_default {
    type      = number;
    component = field;
};
property spec_access {
    type      = string;
    component = field;
};
property sw_default_mask {
    type      = number;
    component = field;
};
property reset_mask {
    type      = number;
    component = field;
};
regfile regs_NVDLA_RBK{
    default regwidth=32;
    reg {
        name = "S_STATUS";
        desc = "
////Rubik Engine Registers
";
        enum S_STATUS_STATUS_0_enum {
            IDLE = 2'd0;
            RUNNING = 2'd1;
            PENDING = 2'd2;
        };
        field {
            encode          = S_STATUS_STATUS_0_enum;
            sw              = r;
            hw              = w;
            spec_access     = r;
            reset           = 0x0;
            reset_mask      = 0x3;
            spec_sw_default = 0x0;
            sw_default_mask = 0x0;
        } STATUS_0[1:0];
        STATUS_0->desc="
//// Status of configuration register group 0
";
        enum S_STATUS_STATUS_1_enum {
            IDLE = 2'd0;
            RUNNING = 2'd1;
            PENDING = 2'd2;
        };
        field {
            encode          = S_STATUS_STATUS_1_enum;
            sw              = r;
            hw              = w;
            spec_access     = r;
            reset           = 0x0;
            reset_mask      = 0x3;
            spec_sw_default = 0x0;
            sw_default_mask = 0x0;
        } STATUS_1[17:16];
        STATUS_1->desc="
//// Status of configuration register group 1
";
    }S_STATUS @0x0;
    reg {
        name = "S_POINTER";
        enum S_POINTER_PRODUCER_enum {
            GROUP_0 = 1'd0;
            GROUP_1 = 1'd1;
        };
        field {
            encode          = S_POINTER_PRODUCER_enum;
            sw              = rw;
            hw              = r;
            spec_access     = rw;
            reset           = 0x0;
            reset_mask      = 0x1;
            spec_sw_default = 0x0;
            sw_default_mask = 0x0;
        } PRODUCER[0:0];
        PRODUCER->desc="
////Pointer for CSB master to access groups
";
        enum S_POINTER_CONSUMER_enum {
            GROUP_0 = 1'd0;
            GROUP_1 = 1'd1;
        };
        field {
            encode          = S_POINTER_CONSUMER_enum;
            sw              = r;
            hw              = w;
            spec_access     = r;
            reset           = 0x0;
            reset_mask      = 0x1;
            spec_sw_default = 0x0;
            sw_default_mask = 0x0;
        } CONSUMER[16:16];
        CONSUMER->desc="
////Pointer for datapath to access groups
";
    }S_POINTER @0x4;
    reg {
        name = "D_OP_ENABLE";
        desc = "
//////////////////////////////////////////////////////////////////////////////////
////                                                                            //
////                    Define single group registers here                      //
////                    Register name should shart with prefix D_               //
////                                                                            //
//////////////////////////////////////////////////////////////////////////////////
//// 
";
        enum D_OP_ENABLE_OP_EN_enum {
            DISABLE = 1'd0;
            ENABLE = 1'd1;
        };
        field {
            encode          = D_OP_ENABLE_OP_EN_enum;
            sw              = rw;
            hw              = r;
            spec_access     = rwto;
            reset           = 0x0;
            reset_mask      = 0x1;
            spec_sw_default = 0x0;
            sw_default_mask = 0x0;
        } OP_EN[0:0];
    }D_OP_ENABLE @0x8;
    reg {
        name = "D_MISC_CFG";
        enum D_MISC_CFG_RUBIK_MODE_enum {
            CONTRACT = 2'd0;
            SPLIT = 2'd1;
            MERGE = 2'd2;
        };
        field {
            encode          = D_MISC_CFG_RUBIK_MODE_enum;
            sw              = rw;
            hw              = r;
            spec_access     = rw;
            reset           = 0x0;
            reset_mask      = 0x3;
            spec_sw_default = 0x0;
            sw_default_mask = 0x0;
        } RUBIK_MODE[1:0];
        enum D_MISC_CFG_IN_PRECISION_enum {
            INT8 = 2'd0;
            INT16 = 2'd1;
            FP16 = 2'd2;
        };
        field {
            encode          = D_MISC_CFG_IN_PRECISION_enum;
            sw              = rw;
            hw              = r;
            spec_access     = rw;
            reset           = 0x1;
            reset_mask      = 0x3;
            spec_sw_default = 0x0;
            sw_default_mask = 0x0;
        } IN_PRECISION[9:8];
    }D_MISC_CFG @0xc;
    reg {
        name = "D_DAIN_RAM_TYPE";
        enum D_DAIN_RAM_TYPE_DATAIN_RAM_TYPE_enum {
            CVIF = 1'd0;
            MCIF = 1'd1;
        };
        field {
            encode          = D_DAIN_RAM_TYPE_DATAIN_RAM_TYPE_enum;
            sw              = rw;
            hw              = r;
            spec_access     = rw;
            reset           = 0x0;
            reset_mask      = 0x1;
            spec_sw_default = 0x0;
            sw_default_mask = 0x0;
        } DATAIN_RAM_TYPE[0:0];
        DATAIN_RAM_TYPE->desc="
////indicate the source ram (CV or MC)
";
    }D_DAIN_RAM_TYPE @0x10;
    reg {
        name = "D_DATAIN_SIZE_0";
        field {
            sw              = rw;
            hw              = r;
            spec_access     = rw;
            reset           = 0x0;
            reset_mask      = 0x1fff;
            spec_sw_default = 0x0;
            sw_default_mask = 0x0;
        } DATAIN_WIDTH[12:0];
        DATAIN_WIDTH->desc="
////Input data cube width - 1
";
        field {
            sw              = rw;
            hw              = r;
            spec_access     = rw;
            reset           = 0x0;
            reset_mask      = 0x1fff;
            spec_sw_default = 0x0;
            sw_default_mask = 0x0;
        } DATAIN_HEIGHT[28:16];
        DATAIN_HEIGHT->desc="
////Input data cube height - 1
";
    }D_DATAIN_SIZE_0 @0x14;
    reg {
        name = "D_DATAIN_SIZE_1";
        field {
            sw              = rw;
            hw              = r;
            spec_access     = rw;
            reset           = 0x0;
            reset_mask      = 0x1fff;
            spec_sw_default = 0x0;
            sw_default_mask = 0x0;
        } DATAIN_CHANNEL[12:0];
        DATAIN_CHANNEL->desc="
////Input data cube channel - 1
";
    }D_DATAIN_SIZE_1 @0x18;
    reg {
        name = "D_DAIN_ADDR_HIGH";
        field {
            sw              = rw;
            hw              = r;
            spec_access     = rw;
            reset           = 0x0;
            reset_mask      = 0xffffffff;
            spec_sw_default = 0x0;
            sw_default_mask = 0x0;
        } DAIN_ADDR_HIGH[31:0];
        DAIN_ADDR_HIGH->desc="
////Input data address, high 8 bits
";
    }D_DAIN_ADDR_HIGH @0x1c;
    reg {
        name = "D_DAIN_ADDR_LOW";
        field {
            sw              = rw;
            hw              = r;
            spec_access     = rw;
            reset           = 0x0;
            reset_mask      = 0x7ffffff;
            spec_sw_default = 0x0;
            sw_default_mask = 0x0;
        } DAIN_ADDR_LOW[31:5];
        DAIN_ADDR_LOW->desc="
////Input data address, low 32 bits
";
    }D_DAIN_ADDR_LOW @0x20;
    reg {
        name = "D_DAIN_LINE_STRIDE";
        field {
            sw              = rw;
            hw              = r;
            spec_access     = rw;
            reset           = 0x0;
            reset_mask      = 0x7ffffff;
            spec_sw_default = 0x0;
            sw_default_mask = 0x0;
        } DAIN_LINE_STRIDE[31:5];
        DAIN_LINE_STRIDE->desc="
////Input data line stride, bytes
";
    }D_DAIN_LINE_STRIDE @0x24;
    reg {
        name = "D_DAIN_SURF_STRIDE";
        field {
            sw              = rw;
            hw              = r;
            spec_access     = rw;
            reset           = 0x0;
            reset_mask      = 0x7ffffff;
            spec_sw_default = 0x0;
            sw_default_mask = 0x0;
        } DAIN_SURF_STRIDE[31:5];
        DAIN_SURF_STRIDE->desc="
////Input data surface stride, bytes
";
    }D_DAIN_SURF_STRIDE @0x28;
    reg {
        name = "D_DAIN_PLANAR_STRIDE";
        field {
            sw              = rw;
            hw              = r;
            spec_access     = rw;
            reset           = 0x0;
            reset_mask      = 0x7ffffff;
            spec_sw_default = 0x0;
            sw_default_mask = 0x0;
        } DAIN_PLANAR_STRIDE[31:5];
        DAIN_PLANAR_STRIDE->desc="
////Input data planar stride, for merge mode only, bytes
";
    }D_DAIN_PLANAR_STRIDE @0x2c;
    reg {
        name = "D_DAOUT_RAM_TYPE";
        enum D_DAOUT_RAM_TYPE_DATAOUT_RAM_TYPE_enum {
            CVIF = 1'd0;
            MCIF = 1'd1;
        };
        field {
            encode          = D_DAOUT_RAM_TYPE_DATAOUT_RAM_TYPE_enum;
            sw              = rw;
            hw              = r;
            spec_access     = rw;
            reset           = 0x0;
            reset_mask      = 0x1;
            spec_sw_default = 0x0;
            sw_default_mask = 0x0;
        } DATAOUT_RAM_TYPE[0:0];
        DATAOUT_RAM_TYPE->desc="
////indicate the source ram (CV or MC)
";
    }D_DAOUT_RAM_TYPE @0x30;
    reg {
        name = "D_DATAOUT_SIZE_1";
        field {
            sw              = rw;
            hw              = r;
            spec_access     = rw;
            reset           = 0x0;
            reset_mask      = 0x1fff;
            spec_sw_default = 0x0;
            sw_default_mask = 0x0;
        } DATAOUT_CHANNEL[12:0];
        DATAOUT_CHANNEL->desc="
////Output data cube channel - 1
";
    }D_DATAOUT_SIZE_1 @0x34;
    reg {
        name = "D_DAOUT_ADDR_HIGH";
        field {
            sw              = rw;
            hw              = r;
            spec_access     = rw;
            reset           = 0x0;
            reset_mask      = 0xffffffff;
            spec_sw_default = 0x0;
            sw_default_mask = 0x0;
        } DAOUT_ADDR_HIGH[31:0];
        DAOUT_ADDR_HIGH->desc="
////Output data address, high 8 bits
";
    }D_DAOUT_ADDR_HIGH @0x38;
    reg {
        name = "D_DAOUT_ADDR_LOW";
        field {
            sw              = rw;
            hw              = r;
            spec_access     = rw;
            reset           = 0x0;
            reset_mask      = 0x7ffffff;
            spec_sw_default = 0x0;
            sw_default_mask = 0x0;
        } DAOUT_ADDR_LOW[31:5];
        DAOUT_ADDR_LOW->desc="
////Output data address, low 32 bits
";
    }D_DAOUT_ADDR_LOW @0x3c;
    reg {
        name = "D_DAOUT_LINE_STRIDE";
        field {
            sw              = rw;
            hw              = r;
            spec_access     = rw;
            reset           = 0x0;
            reset_mask      = 0x7ffffff;
            spec_sw_default = 0x0;
            sw_default_mask = 0x0;
        } DAOUT_LINE_STRIDE[31:5];
        DAOUT_LINE_STRIDE->desc="
////Output data line stride, bytes
";
    }D_DAOUT_LINE_STRIDE @0x40;
    reg {
        name = "D_CONTRACT_STRIDE_0";
        field {
            sw              = rw;
            hw              = r;
            spec_access     = rw;
            reset           = 0x0;
            reset_mask      = 0x7ffffff;
            spec_sw_default = 0x0;
            sw_default_mask = 0x0;
        } CONTRACT_STRIDE_0[31:5];
        CONTRACT_STRIDE_0->desc="
////(DATAOUT_CHANNEL+1) * BPE / 32 * DAIN_SURF_STRIDE 
";
    }D_CONTRACT_STRIDE_0 @0x44;
    reg {
        name = "D_CONTRACT_STRIDE_1";
        desc = "
////BPE = (IN_PRECISION == INT8) ? 1 : 2;
";
        field {
            sw              = rw;
            hw              = r;
            spec_access     = rw;
            reset           = 0x0;
            reset_mask      = 0x7ffffff;
            spec_sw_default = 0x0;
            sw_default_mask = 0x0;
        } CONTRACT_STRIDE_1[31:5];
        CONTRACT_STRIDE_1->desc="
////(DECONV_Y_STRIDE+1) * DAOUT_LINE_STRIDE
";
    }D_CONTRACT_STRIDE_1 @0x48;
    reg {
        name = "D_DAOUT_SURF_STRIDE";
        field {
            sw              = rw;
            hw              = r;
            spec_access     = rw;
            reset           = 0x0;
            reset_mask      = 0x7ffffff;
            spec_sw_default = 0x0;
            sw_default_mask = 0x0;
        } DAOUT_SURF_STRIDE[31:5];
        DAOUT_SURF_STRIDE->desc="
////Output data surface stride, bytes
";
    }D_DAOUT_SURF_STRIDE @0x4c;
    reg {
        name = "D_DAOUT_PLANAR_STRIDE";
        field {
            sw              = rw;
            hw              = r;
            spec_access     = rw;
            reset           = 0x0;
            reset_mask      = 0x7ffffff;
            spec_sw_default = 0x0;
            sw_default_mask = 0x0;
        } DAOUT_PLANAR_STRIDE[31:5];
        DAOUT_PLANAR_STRIDE->desc="
////Output data planar stride, for split mode only, bytes
";
    }D_DAOUT_PLANAR_STRIDE @0x50;
    reg {
        name = "D_DECONV_STRIDE";
        field {
            sw              = rw;
            hw              = r;
            spec_access     = rw;
            reset           = 0x0;
            reset_mask      = 0x1f;
            spec_sw_default = 0x0;
            sw_default_mask = 0x0;
        } DECONV_X_STRIDE[4:0];
        DECONV_X_STRIDE->desc="
////deconvolution x stride - 1
";
        field {
            sw              = rw;
            hw              = r;
            spec_access     = rw;
            reset           = 0x0;
            reset_mask      = 0x1f;
            spec_sw_default = 0x0;
            sw_default_mask = 0x0;
        } DECONV_Y_STRIDE[20:16];
        DECONV_Y_STRIDE->desc="
////deconvolution y stride - 1
";
    }D_DECONV_STRIDE @0x54;
    reg {
        name = "D_PERF_ENABLE";
        desc = "
////performance register
";
        field {
            sw              = rw;
            hw              = r;
            spec_access     = rw;
            reset           = 0x0;
            reset_mask      = 0x1;
            spec_sw_default = 0x0;
            sw_default_mask = 0x0;
        } PERF_EN[0:0];
        PERF_EN->desc="
////Control register to enable/disable perf Counter 
";
    }D_PERF_ENABLE @0x58;
    reg {
        name = "D_PERF_READ_STALL";
        field {
            sw              = r;
            hw              = w;
            spec_access     = r;
            reset           = 0x0;
            reset_mask      = 0xffffffff;
            spec_sw_default = 0x0;
            sw_default_mask = 0x0;
        } RD_STALL_CNT[31:0];
        RD_STALL_CNT->desc="
////RD_STALL Count stall cycles of read DMA for one layer 
";
    }D_PERF_READ_STALL @0x5c;
    reg {
        name = "D_PERF_WRITE_STALL";
        field {
            sw              = r;
            hw              = w;
            spec_access     = r;
            reset           = 0x0;
            reset_mask      = 0xffffffff;
            spec_sw_default = 0x0;
            sw_default_mask = 0x0;
        } WR_STALL_CNT[31:0];
        WR_STALL_CNT->desc="
////WR_STALL Count stall cycles of wirte DMA for one layer 
";
    }D_PERF_WRITE_STALL @0x60;
};
addrmap  {
    regs_NVDLA_RBK NVDLA_RBK @0x11000;
}addrmap_NVDLA;
